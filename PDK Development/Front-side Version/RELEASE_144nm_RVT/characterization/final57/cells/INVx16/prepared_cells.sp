*
*|DSPF 1.3
*|DESIGN INVx16
*|DATE "Tue Nov  3 20:49:58 2026"
*|VENDOR "Synopsys"
*|PROGRAM "StarRC"
*|VERSION "X-2025.06-SP1"
*|DIVIDER /
*|DELIMITER :
**FORMAT SPF
*

** COMMENTS

** OPERATING_TEMPERATURE 25
** GLOBAL_TEMPERATURE 25
**
** TCAD_GRD_FILE /cedar/cedar_coe/ece-limsk/yhuang861/GRO/.planning/experiments_migrated_20261022/usc144_github_release_20261103/sources/github_FSPR.nxtgrd
**   TCAD_TIME_STAMP Tue Mar 31 05:07:55 2026
**   TCADGRD_VERSION 89

.SUBCKT INVx16 VSS VDD A Y

*|GROUND_NET VSS

*|NET VSS 0.000148117PF
*|P (VSS B 0 0.3570 0.0000)
*|I (M1:DRN M1 DRN B 0 0.6780 0.0360)
*|I (M10:SRC M10 SRC B 0 0.2880 0.0360)
*|I (M11:DRN M11 DRN B 0 0.2580 0.0360)
*|I (M12:SRC M12 SRC B 0 0.2040 0.0360)
*|I (M13:DRN M13 DRN B 0 0.1740 0.0360)
*|I (M14:SRC M14 SRC B 0 0.1200 0.0360)
*|I (M15:DRN M15 DRN B 0 0.0900 0.0360)
*|I (M16:SRC M16 SRC B 0 0.0360 0.0360)
*|I (M2:SRC M2 SRC B 0 0.6240 0.0360)
*|I (M3:DRN M3 DRN B 0 0.5940 0.0360)
*|I (M4:SRC M4 SRC B 0 0.5400 0.0360)
*|I (M5:DRN M5 DRN B 0 0.5100 0.0360)
*|I (M6:SRC M6 SRC B 0 0.4560 0.0360)
*|I (M7:DRN M7 DRN B 0 0.4260 0.0360)
*|I (M8:SRC M8 SRC B 0 0.3720 0.0360)
*|I (M9:DRN M9 DRN B 0 0.3420 0.0360)
Cg1_1 VSS:18 VSS 2.68769e-19
Cg1_2 VSS:19 VSS 2.77026e-19
Cg1_3 VSS:20 VSS 2.77026e-19
Cg1_4 VSS:21 VSS 2.77026e-19
Cg1_5 VSS:22 VSS 2.77026e-19
Cg1_6 VSS:23 VSS 2.77026e-19
Cg1_7 VSS:24 VSS 2.77026e-19
Cg1_8 VSS:25 VSS 2.77026e-19
Cg1_9 VSS:26 VSS 1.78742e-19
Cg1_10 VSS:35 VSS 5.37033e-18
Cg1_11 VSS:45 VSS 9.48256e-18
Cg1_12 VSS:46 VSS 9.48256e-18
Cg1_13 VSS:47 VSS 6.26949e-19
Cg1_14 VSS:48 VSS 5.28034e-19
Cg1_15 VSS:49 VSS 4.84383e-19
Cg1_16 VSS:50 VSS 5.15349e-19
Cg1_17 VSS:51 VSS 5.16095e-19
Cg1_18 VSS:52 VSS 4.72445e-19
Cg1_19 VSS:53 VSS 5.20199e-19
Cg1_20 VSS:54 VSS 4.87561e-19
R1_1 VSS VSS:30 50.1665
R1_2 VSS VSS:31 50.1665
R1_3 VSS VSS:50 31.764
R1_4 M1:DRN VSS:44 30000.0
R1_5 M1:DRN VSS:26 30000.0
R1_6 M1:DRN VSS:73 15000.0
R1_7 M10:SRC VSS:39 30000.0
R1_8 M10:SRC VSS:21 30000.0
R1_9 M10:SRC VSS:63 15000.0
R1_10 M11:DRN VSS:39 30000.0
R1_11 M11:DRN VSS:21 30000.0
R1_12 M11:DRN VSS:63 15000.0
R1_13 M12:SRC VSS:38 30000.0
R1_14 M12:SRC VSS:20 30000.0
R1_15 M12:SRC VSS:61 15000.0
R1_16 M13:DRN VSS:38 30000.0
R1_17 M13:DRN VSS:20 30000.0
R1_18 M13:DRN VSS:61 15000.0
R1_19 M14:SRC VSS:37 30000.0
R1_20 M14:SRC VSS:19 30000.0
R1_21 M14:SRC VSS:59 15000.0
R1_22 M15:DRN VSS:37 30000.0
R1_23 M15:DRN VSS:19 30000.0
R1_24 M15:DRN VSS:59 15000.0
R1_25 M16:SRC VSS:36 30000.0
R1_26 M16:SRC VSS:18 30000.0
R1_27 M16:SRC VSS:57 15000.0
R1_28 M2:SRC VSS:43 30000.0
R1_29 M2:SRC VSS:25 30000.0
R1_30 M2:SRC VSS:71 15000.0
R1_31 M3:DRN VSS:43 30000.0
R1_32 M3:DRN VSS:25 30000.0
R1_33 M3:DRN VSS:71 15000.0
R1_34 M4:SRC VSS:42 30000.0
R1_35 M4:SRC VSS:24 30000.0
R1_36 M4:SRC VSS:69 15000.0
R1_37 M5:DRN VSS:42 30000.0
R1_38 M5:DRN VSS:24 30000.0
R1_39 M5:DRN VSS:69 15000.0
R1_40 M6:SRC VSS:41 30000.0
R1_41 M6:SRC VSS:23 30000.0
R1_42 M6:SRC VSS:67 15000.0
R1_43 M7:DRN VSS:41 30000.0
R1_44 M7:DRN VSS:23 30000.0
R1_45 M7:DRN VSS:67 15000.0
R1_46 M8:SRC VSS:40 30000.0
R1_47 M8:SRC VSS:22 30000.0
R1_48 M8:SRC VSS:65 15000.0
R1_49 M9:DRN VSS:40 30000.0
R1_50 M9:DRN VSS:22 30000.0
R1_51 M9:DRN VSS:65 15000.0
R1_52 VSS:18 VSS:57 7.8411
R1_53 VSS:18 VSS:54 12.4587
R1_54 VSS:19 VSS:59 7.84041
R1_55 VSS:19 VSS:53 12.4587
R1_56 VSS:20 VSS:61 7.84041
R1_57 VSS:20 VSS:52 12.4587
R1_58 VSS:21 VSS:63 7.84041
R1_59 VSS:21 VSS:51 12.4587
R1_60 VSS:22 VSS:65 7.84041
R1_61 VSS:22 VSS:50 12.4587
R1_62 VSS:23 VSS:67 7.84041
R1_63 VSS:23 VSS:49 12.4587
R1_64 VSS:24 VSS:69 7.84041
R1_65 VSS:24 VSS:48 12.4587
R1_66 VSS:25 VSS:71 7.84041
R1_67 VSS:25 VSS:47 12.4587
R1_68 VSS:26 VSS:73 7.8411
R1_69 VSS:26 VSS:35 12.4587
R1_70 VSS:27 VSS:45 17.9166
R1_71 VSS:27 VSS:28 50.1665
R1_72 VSS:27 VSS:54 31.764
R1_73 VSS:28 VSS:29 50.1665
R1_74 VSS:28 VSS:53 31.764
R1_75 VSS:29 VSS:30 50.1665
R1_76 VSS:29 VSS:52 31.764
R1_77 VSS:30 VSS:51 31.764
R1_78 VSS:31 VSS:32 50.1665
R1_79 VSS:31 VSS:49 31.764
R1_80 VSS:32 VSS:33 50.1665
R1_81 VSS:32 VSS:48 31.764
R1_82 VSS:33 VSS:34 50.1665
R1_83 VSS:33 VSS:47 31.764
R1_84 VSS:34 VSS:35 31.764
R1_85 VSS:34 VSS:46 17.9166
R1_86 VSS:35 VSS:47 100.37
R1_87 VSS:35 VSS:56 34.3372
R1_88 VSS:36 VSS:57 7.8411
R1_89 VSS:36 VSS:58 1.77981
R1_90 VSS:37 VSS:59 7.84041
R1_91 VSS:37 VSS:60 1.77981
R1_92 VSS:38 VSS:61 7.84041
R1_93 VSS:38 VSS:62 1.77981
R1_94 VSS:39 VSS:63 7.84041
R1_95 VSS:39 VSS:64 1.77981
R1_96 VSS:40 VSS:65 7.84041
R1_97 VSS:40 VSS:66 1.77981
R1_98 VSS:41 VSS:67 7.84041
R1_99 VSS:41 VSS:68 1.77981
R1_100 VSS:42 VSS:69 7.84041
R1_101 VSS:42 VSS:70 1.77981
R1_102 VSS:43 VSS:71 7.84041
R1_103 VSS:43 VSS:72 1.77981
R1_104 VSS:44 VSS:73 7.8411
R1_105 VSS:44 VSS:74 1.77981
R1_106 VSS:47 VSS:48 100.37
R1_107 VSS:48 VSS:49 100.37
R1_108 VSS:49 VSS:50 100.37
R1_109 VSS:50 VSS:51 100.37
R1_110 VSS:51 VSS:52 100.37
R1_111 VSS:52 VSS:53 100.37
R1_112 VSS:53 VSS:54 100.37
R1_113 VSS:54 VSS:55 34.3372

*|NET VDD 0.000160972PF
*|P (VDD B 0 0.3570 0.1440)
*|I (M17:DRN M17 DRN B 0 0.6780 0.1080)
*|I (M18:SRC M18 SRC B 0 0.6240 0.1080)
*|I (M19:DRN M19 DRN B 0 0.5940 0.1080)
*|I (M20:SRC M20 SRC B 0 0.5400 0.1080)
*|I (M21:DRN M21 DRN B 0 0.5100 0.1080)
*|I (M22:SRC M22 SRC B 0 0.4560 0.1080)
*|I (M23:DRN M23 DRN B 0 0.4260 0.1080)
*|I (M24:SRC M24 SRC B 0 0.3720 0.1080)
*|I (M25:DRN M25 DRN B 0 0.3420 0.1080)
*|I (M26:SRC M26 SRC B 0 0.2880 0.1080)
*|I (M27:DRN M27 DRN B 0 0.2580 0.1080)
*|I (M28:SRC M28 SRC B 0 0.2040 0.1080)
*|I (M29:DRN M29 DRN B 0 0.1740 0.1080)
*|I (M30:SRC M30 SRC B 0 0.1200 0.1080)
*|I (M31:DRN M31 DRN B 0 0.0900 0.1080)
*|I (M32:SRC M32 SRC B 0 0.0360 0.1080)
C2_1 VDD:28 VSS:35 6.39187e-20
C2_2 VDD:43 VSS:35 4.19119e-19
C2_3 VDD:44 VSS:35 6.70033e-21
C2_4 VDD:52 VSS:35 2.00992e-20
C2_5 VDD:53 VSS:35 3.89502e-20
C2_6 VDD:54 VSS:35 3.89502e-20
C2_7 VDD:43 VSS:45 1.38141e-20
C2_8 VDD:53 VSS:45 2.97648e-19
C2_9 VDD:43 VSS:46 1.38141e-20
C2_10 VDD:54 VSS:46 2.97648e-19
C2_11 VDD:41 VSS:47 4.65622e-19
C2_12 VDD:51 VSS:47 2.24891e-20
C2_13 VDD:39 VSS:48 4.65622e-19
C2_14 VDD:50 VSS:48 2.24891e-20
C2_15 VDD:37 VSS:49 4.65622e-19
C2_16 VDD:49 VSS:49 2.24891e-20
C2_17 VDD:35 VSS:50 4.65622e-19
C2_18 VDD:48 VSS:50 2.24891e-20
C2_19 VDD:34 VSS:51 4.65622e-19
C2_20 VDD:47 VSS:51 2.24891e-20
C2_21 VDD:32 VSS:52 4.65622e-19
C2_22 VDD:46 VSS:52 2.24891e-20
C2_23 VDD:30 VSS:53 4.65622e-19
C2_24 VDD:45 VSS:53 2.24891e-20
C2_25 VDD:28 VSS:54 4.49535e-19
C2_26 VDD:44 VSS:54 2.26115e-20
Cg2_27 VDD:18 VSS 2.68918e-19
Cg2_28 VDD:19 VSS 2.77231e-19
Cg2_29 VDD:20 VSS 2.77231e-19
Cg2_30 VDD:21 VSS 2.77231e-19
Cg2_31 VDD:22 VSS 2.77231e-19
Cg2_32 VDD:23 VSS 2.77231e-19
Cg2_33 VDD:24 VSS 2.77231e-19
Cg2_34 VDD:25 VSS 2.77231e-19
Cg2_35 VDD:26 VSS 1.78742e-19
Cg2_36 VDD:28 VSS 8.08969e-19
Cg2_37 VDD:30 VSS 8.31859e-19
Cg2_38 VDD:32 VSS 7.84101e-19
Cg2_39 VDD:34 VSS 8.27755e-19
Cg2_40 VDD:35 VSS 8.27009e-19
Cg2_41 VDD:37 VSS 7.9604e-19
Cg2_42 VDD:39 VSS 8.39694e-19
Cg2_43 VDD:41 VSS 8.20452e-19
Cg2_44 VDD:43 VSS 3.37087e-17
Cg2_45 VDD:44 VSS 5.43919e-21
Cg2_46 VDD:53 VSS 9.46664e-18
Cg2_47 VDD:54 VSS 9.46664e-18
R2_1 VDD VDD:33 50.1665
R2_2 VDD VDD:36 50.1665
R2_3 VDD VDD:35 31.764
R2_4 M17:DRN VDD:52 30000.0
R2_5 M17:DRN VDD:26 30000.0
R2_6 M17:DRN VDD:73 15000.0
R2_7 M18:SRC VDD:51 30000.0
R2_8 M18:SRC VDD:25 30000.0
R2_9 M18:SRC VDD:71 15000.0
R2_10 M19:DRN VDD:51 30000.0
R2_11 M19:DRN VDD:25 30000.0
R2_12 M19:DRN VDD:71 15000.0
R2_13 M20:SRC VDD:50 30000.0
R2_14 M20:SRC VDD:24 30000.0
R2_15 M20:SRC VDD:69 15000.0
R2_16 M21:DRN VDD:50 30000.0
R2_17 M21:DRN VDD:24 30000.0
R2_18 M21:DRN VDD:69 15000.0
R2_19 M22:SRC VDD:49 30000.0
R2_20 M22:SRC VDD:23 30000.0
R2_21 M22:SRC VDD:67 15000.0
R2_22 M23:DRN VDD:49 30000.0
R2_23 M23:DRN VDD:23 30000.0
R2_24 M23:DRN VDD:67 15000.0
R2_25 M24:SRC VDD:48 30000.0
R2_26 M24:SRC VDD:22 30000.0
R2_27 M24:SRC VDD:65 15000.0
R2_28 M25:DRN VDD:48 30000.0
R2_29 M25:DRN VDD:22 30000.0
R2_30 M25:DRN VDD:65 15000.0
R2_31 M26:SRC VDD:47 30000.0
R2_32 M26:SRC VDD:21 30000.0
R2_33 M26:SRC VDD:63 15000.0
R2_34 M27:DRN VDD:47 30000.0
R2_35 M27:DRN VDD:21 30000.0
R2_36 M27:DRN VDD:63 15000.0
R2_37 M28:SRC VDD:46 30000.0
R2_38 M28:SRC VDD:20 30000.0
R2_39 M28:SRC VDD:61 15000.0
R2_40 M29:DRN VDD:46 30000.0
R2_41 M29:DRN VDD:20 30000.0
R2_42 M29:DRN VDD:61 15000.0
R2_43 M30:SRC VDD:45 30000.0
R2_44 M30:SRC VDD:19 30000.0
R2_45 M30:SRC VDD:59 15000.0
R2_46 M31:DRN VDD:45 30000.0
R2_47 M31:DRN VDD:19 30000.0
R2_48 M31:DRN VDD:59 15000.0
R2_49 M32:SRC VDD:44 30000.0
R2_50 M32:SRC VDD:18 30000.0
R2_51 M32:SRC VDD:57 15000.0
R2_52 VDD:18 VDD:57 7.8411
R2_53 VDD:18 VDD:58 1.77981
R2_54 VDD:19 VDD:59 7.84041
R2_55 VDD:19 VDD:60 1.77981
R2_56 VDD:20 VDD:61 7.84041
R2_57 VDD:20 VDD:62 1.77981
R2_58 VDD:21 VDD:63 7.84041
R2_59 VDD:21 VDD:64 1.77981
R2_60 VDD:22 VDD:65 7.84041
R2_61 VDD:22 VDD:66 1.77981
R2_62 VDD:23 VDD:67 7.84041
R2_63 VDD:23 VDD:68 1.77981
R2_64 VDD:24 VDD:69 7.84041
R2_65 VDD:24 VDD:70 1.77981
R2_66 VDD:25 VDD:71 7.84041
R2_67 VDD:25 VDD:72 1.77981
R2_68 VDD:26 VDD:73 7.8411
R2_69 VDD:26 VDD:74 1.77981
R2_70 VDD:27 VDD:28 31.764
R2_71 VDD:27 VDD:53 17.9166
R2_72 VDD:27 VDD:29 50.1665
R2_73 VDD:28 VDD:55 34.3372
R2_74 VDD:28 VDD:30 100.37
R2_75 VDD:28 VDD:44 12.4587
R2_76 VDD:29 VDD:30 31.764
R2_77 VDD:29 VDD:31 50.1665
R2_78 VDD:30 VDD:32 100.37
R2_79 VDD:30 VDD:45 12.4587
R2_80 VDD:31 VDD:32 31.764
R2_81 VDD:31 VDD:33 50.1665
R2_82 VDD:32 VDD:34 100.37
R2_83 VDD:32 VDD:46 12.4587
R2_84 VDD:33 VDD:34 31.764
R2_85 VDD:34 VDD:35 100.37
R2_86 VDD:34 VDD:47 12.4587
R2_87 VDD:35 VDD:37 100.37
R2_88 VDD:35 VDD:48 12.4587
R2_89 VDD:36 VDD:37 31.764
R2_90 VDD:36 VDD:38 50.1665
R2_91 VDD:37 VDD:39 100.37
R2_92 VDD:37 VDD:49 12.4587
R2_93 VDD:38 VDD:39 31.764
R2_94 VDD:38 VDD:40 50.1665
R2_95 VDD:39 VDD:41 100.37
R2_96 VDD:39 VDD:50 12.4587
R2_97 VDD:40 VDD:41 31.764
R2_98 VDD:40 VDD:42 50.1665
R2_99 VDD:41 VDD:43 100.37
R2_100 VDD:41 VDD:51 12.4587
R2_101 VDD:42 VDD:43 31.764
R2_102 VDD:42 VDD:54 17.9166
R2_103 VDD:43 VDD:56 34.3372
R2_104 VDD:43 VDD:52 12.4587
R2_105 VDD:44 VDD:57 7.8411
R2_106 VDD:45 VDD:59 7.84041
R2_107 VDD:46 VDD:61 7.84041
R2_108 VDD:47 VDD:63 7.84041
R2_109 VDD:48 VDD:65 7.84041
R2_110 VDD:49 VDD:67 7.84041
R2_111 VDD:50 VDD:69 7.84041
R2_112 VDD:51 VDD:71 7.84041
R2_113 VDD:52 VDD:73 7.8411

*|NET A 0.000125852PF
*|P (A B 0 0.0210 0.0720)
*|I (M1:GATE M1 GATE I 3.6e-19 0.6720 0.0360)
*|I (M10:GATE M10 GATE I 3.6e-19 0.2940 0.0360)
*|I (M11:GATE M11 GATE I 3.6e-19 0.2520 0.0360)
*|I (M12:GATE M12 GATE I 3.6e-19 0.2100 0.0360)
*|I (M13:GATE M13 GATE I 3.6e-19 0.1680 0.0360)
*|I (M14:GATE M14 GATE I 3.6e-19 0.1260 0.0360)
*|I (M15:GATE M15 GATE I 3.6e-19 0.0840 0.0360)
*|I (M16:GATE M16 GATE I 3.6e-19 0.0420 0.0360)
*|I (M17:GATE M17 GATE I 3.6e-19 0.6720 0.1080)
*|I (M18:GATE M18 GATE I 3.6e-19 0.6300 0.1080)
*|I (M19:GATE M19 GATE I 3.6e-19 0.5880 0.1080)
*|I (M2:GATE M2 GATE I 3.6e-19 0.6300 0.0360)
*|I (M20:GATE M20 GATE I 3.6e-19 0.5460 0.1080)
*|I (M21:GATE M21 GATE I 3.6e-19 0.5040 0.1080)
*|I (M22:GATE M22 GATE I 3.6e-19 0.4620 0.1080)
*|I (M23:GATE M23 GATE I 3.6e-19 0.4200 0.1080)
*|I (M24:GATE M24 GATE I 3.6e-19 0.3780 0.1080)
*|I (M25:GATE M25 GATE I 3.6e-19 0.3360 0.1080)
*|I (M26:GATE M26 GATE I 3.6e-19 0.2940 0.1080)
*|I (M27:GATE M27 GATE I 3.6e-19 0.2520 0.1080)
*|I (M28:GATE M28 GATE I 3.6e-19 0.2100 0.1080)
*|I (M29:GATE M29 GATE I 3.6e-19 0.1680 0.1080)
*|I (M3:GATE M3 GATE I 3.6e-19 0.5880 0.0360)
*|I (M30:GATE M30 GATE I 3.6e-19 0.1260 0.1080)
*|I (M31:GATE M31 GATE I 3.6e-19 0.0840 0.1080)
*|I (M32:GATE M32 GATE I 3.6e-19 0.0420 0.1080)
*|I (M4:GATE M4 GATE I 3.6e-19 0.5460 0.0360)
*|I (M5:GATE M5 GATE I 3.6e-19 0.5040 0.0360)
*|I (M6:GATE M6 GATE I 3.6e-19 0.4620 0.0360)
*|I (M7:GATE M7 GATE I 3.6e-19 0.4200 0.0360)
*|I (M8:GATE M8 GATE I 3.6e-19 0.3780 0.0360)
*|I (M9:GATE M9 GATE I 3.6e-19 0.3360 0.0360)
C3_1 A:144 VSS:18 2.64712e-19
C3_2 A:104 VSS:25 1.23247e-18
C3_3 A VSS:35 1.11057e-20
C3_4 A:34 VSS:35 4.60642e-19
C3_5 A:35 VSS:35 7.89427e-21
C3_6 A:38 VSS:35 4.59524e-19
C3_7 A:39 VSS:35 7.89427e-21
C3_8 A:43 VSS:35 4.59524e-19
C3_9 A:44 VSS:35 7.89427e-21
C3_10 A:48 VSS:35 4.59524e-19
C3_11 A:49 VSS:35 7.89427e-21
C3_12 A:53 VSS:35 4.59524e-19
C3_13 A:54 VSS:35 7.89427e-21
C3_14 A:58 VSS:35 4.59524e-19
C3_15 A:59 VSS:35 7.89427e-21
C3_16 A:63 VSS:35 4.59524e-19
C3_17 A:64 VSS:35 7.89427e-21
C3_18 A:68 VSS:35 4.59524e-19
C3_19 A:69 VSS:35 7.89427e-21
C3_20 A:73 VSS:35 4.59524e-19
C3_21 A:74 VSS:35 7.89427e-21
C3_22 A:78 VSS:35 4.59524e-19
C3_23 A:79 VSS:35 7.89427e-21
C3_24 A:83 VSS:35 4.59524e-19
C3_25 A:84 VSS:35 7.89427e-21
C3_26 A:88 VSS:35 4.59524e-19
C3_27 A:89 VSS:35 7.89427e-21
C3_28 A:93 VSS:35 4.59524e-19
C3_29 A:94 VSS:35 7.89427e-21
C3_30 A:98 VSS:35 4.59524e-19
C3_31 A:99 VSS:35 7.89427e-21
C3_32 A:103 VSS:35 4.60197e-19
C3_33 A:104 VSS:35 7.89427e-21
C3_34 A:108 VSS:35 4.68614e-19
C3_35 A:109 VSS:35 7.89427e-21
C3_36 A:144 VSS:35 9.50471e-20
C3_37 A:145 VSS:35 1.11057e-20
C3_38 A:144 VSS:36 5.1458e-20
C3_39 A VSS:45 1.80969e-18
C3_40 A:34 VSS:45 1.14555e-20
C3_41 A:98 VSS:45 1.29445e-20
C3_42 A:103 VSS:45 2.29027e-20
C3_43 A:108 VSS:45 1.29445e-20
C3_44 A:144 VSS:45 7.10685e-19
C3_45 A:34 VSS:46 1.14555e-20
C3_46 A:98 VSS:46 1.29445e-20
C3_47 A:103 VSS:46 2.29027e-20
C3_48 A:108 VSS:46 1.29445e-20
C3_49 A:144 VSS:46 7.10685e-19
C3_50 A:145 VSS:46 1.80969e-18
C3_51 A VSS:47 1.53396e-19
C3_52 A:98 VSS:47 1.02173e-19
C3_53 A:104 VSS:47 6.91052e-19
C3_54 A:105 VSS:47 1.87735e-19
C3_55 A:108 VSS:47 1.94396e-20
C3_56 A:145 VSS:47 1.53396e-19
C3_57 A VSS:48 1.53396e-19
C3_58 A:145 VSS:48 1.53396e-19
C3_59 A VSS:49 1.53396e-19
C3_60 A:145 VSS:49 1.53396e-19
C3_61 A VSS:50 1.53396e-19
C3_62 A:145 VSS:50 1.53396e-19
C3_63 A VSS:51 1.53396e-19
C3_64 A:145 VSS:51 1.53396e-19
C3_65 A VSS:52 1.53396e-19
C3_66 A:145 VSS:52 1.53396e-19
C3_67 A VSS:53 1.53396e-19
C3_68 A:145 VSS:53 1.53396e-19
C3_69 A VSS:54 1.23731e-19
C3_70 A:144 VSS:54 5.8718e-19
C3_71 A:145 VSS:54 1.23731e-19
C3_72 A:146 VDD:18 1.1494e-19
C3_73 A:106 VDD:25 1.23268e-18
C3_74 A VDD:28 4.9636e-21
C3_75 A:145 VDD:28 4.9636e-21
C3_76 A:146 VDD:28 4.82443e-19
C3_77 A VDD:30 3.31953e-20
C3_78 A:145 VDD:30 3.31953e-20
C3_79 A VDD:32 3.31953e-20
C3_80 A:145 VDD:32 3.31953e-20
C3_81 A VDD:34 3.31953e-20
C3_82 A:145 VDD:34 3.31953e-20
C3_83 A VDD:35 3.31953e-20
C3_84 A:145 VDD:35 3.31953e-20
C3_85 A VDD:37 3.31953e-20
C3_86 A:145 VDD:37 3.31953e-20
C3_87 A VDD:39 3.31953e-20
C3_88 A:145 VDD:39 3.31953e-20
C3_89 A VDD:41 3.31953e-20
C3_90 A:105 VDD:41 1.87735e-19
C3_91 A:106 VDD:41 6.91121e-19
C3_92 A:107 VDD:41 2.55697e-19
C3_93 A:112 VDD:41 3.93596e-22
C3_94 A:145 VDD:41 3.31953e-20
C3_95 A:37 VDD:43 1.14913e-19
C3_96 A:42 VDD:43 1.15217e-19
C3_97 A:47 VDD:43 1.15217e-19
C3_98 A:52 VDD:43 1.15217e-19
C3_99 A:57 VDD:43 1.15217e-19
C3_100 A:62 VDD:43 1.15217e-19
C3_101 A:67 VDD:43 1.15217e-19
C3_102 A:72 VDD:43 1.15217e-19
C3_103 A:77 VDD:43 1.15217e-19
C3_104 A:82 VDD:43 1.15217e-19
C3_105 A:87 VDD:43 1.15217e-19
C3_106 A:92 VDD:43 1.15217e-19
C3_107 A:97 VDD:43 1.15217e-19
C3_108 A:102 VDD:43 1.15217e-19
C3_109 A:107 VDD:43 1.15891e-19
C3_110 A:112 VDD:43 1.24307e-19
C3_111 A:146 VDD:44 1.33203e-19
C3_112 A VDD:53 1.81202e-18
C3_113 A:37 VDD:53 2.86121e-20
C3_114 A:42 VDD:53 2.08871e-20
C3_115 A:47 VDD:53 2.08871e-20
C3_116 A:52 VDD:53 2.08871e-20
C3_117 A:57 VDD:53 2.08871e-20
C3_118 A:62 VDD:53 2.08871e-20
C3_119 A:67 VDD:53 2.08871e-20
C3_120 A:72 VDD:53 2.08871e-20
C3_121 A:77 VDD:53 2.08871e-20
C3_122 A:82 VDD:53 2.08871e-20
C3_123 A:87 VDD:53 2.08871e-20
C3_124 A:92 VDD:53 2.08871e-20
C3_125 A:97 VDD:53 2.08871e-20
C3_126 A:102 VDD:53 2.08871e-20
C3_127 A:107 VDD:53 4.37551e-20
C3_128 A:112 VDD:53 3.38195e-20
C3_129 A:146 VDD:53 7.14641e-19
C3_130 A:37 VDD:54 2.86121e-20
C3_131 A:42 VDD:54 2.08871e-20
C3_132 A:47 VDD:54 2.08871e-20
C3_133 A:52 VDD:54 2.08871e-20
C3_134 A:57 VDD:54 2.08871e-20
C3_135 A:62 VDD:54 2.08871e-20
C3_136 A:67 VDD:54 2.08871e-20
C3_137 A:72 VDD:54 2.08871e-20
C3_138 A:77 VDD:54 2.08871e-20
C3_139 A:82 VDD:54 2.08871e-20
C3_140 A:87 VDD:54 2.08871e-20
C3_141 A:92 VDD:54 2.08871e-20
C3_142 A:97 VDD:54 2.08871e-20
C3_143 A:102 VDD:54 2.08871e-20
C3_144 A:107 VDD:54 4.37551e-20
C3_145 A:112 VDD:54 3.38195e-20
C3_146 A:145 VDD:54 1.81202e-18
C3_147 A:146 VDD:54 7.14641e-19
Cg3_148 A VSS 5.45777e-18
Cg3_149 A:34 VSS 1.08842e-19
Cg3_150 A:36 VSS 3.4119e-19
Cg3_151 A:37 VSS 2.25021e-19
Cg3_152 A:38 VSS 1.09775e-19
Cg3_153 A:40 VSS 3.4119e-19
Cg3_154 A:42 VSS 2.27134e-19
Cg3_155 A:43 VSS 1.09775e-19
Cg3_156 A:45 VSS 3.4119e-19
Cg3_157 A:47 VSS 2.27134e-19
Cg3_158 A:48 VSS 1.09775e-19
Cg3_159 A:50 VSS 3.4119e-19
Cg3_160 A:52 VSS 2.27134e-19
Cg3_161 A:53 VSS 1.09775e-19
Cg3_162 A:55 VSS 3.4119e-19
Cg3_163 A:57 VSS 2.27134e-19
Cg3_164 A:58 VSS 1.09775e-19
Cg3_165 A:60 VSS 3.4119e-19
Cg3_166 A:62 VSS 2.27134e-19
Cg3_167 A:63 VSS 1.09775e-19
Cg3_168 A:65 VSS 3.4119e-19
Cg3_169 A:67 VSS 2.27134e-19
Cg3_170 A:68 VSS 1.09775e-19
Cg3_171 A:70 VSS 3.4119e-19
Cg3_172 A:72 VSS 2.27134e-19
Cg3_173 A:73 VSS 1.09775e-19
Cg3_174 A:75 VSS 3.4119e-19
Cg3_175 A:77 VSS 2.27134e-19
Cg3_176 A:78 VSS 1.09775e-19
Cg3_177 A:80 VSS 3.4119e-19
Cg3_178 A:82 VSS 2.27134e-19
Cg3_179 A:83 VSS 1.09775e-19
Cg3_180 A:85 VSS 3.4119e-19
Cg3_181 A:87 VSS 2.27134e-19
Cg3_182 A:88 VSS 1.09775e-19
Cg3_183 A:90 VSS 3.4119e-19
Cg3_184 A:92 VSS 2.27134e-19
Cg3_185 A:93 VSS 1.09775e-19
Cg3_186 A:95 VSS 3.4119e-19
Cg3_187 A:97 VSS 2.27134e-19
Cg3_188 A:98 VSS 2.08947e-19
Cg3_189 A:100 VSS 3.4119e-19
Cg3_190 A:102 VSS 2.27134e-19
Cg3_191 A:103 VSS 1.00471e-19
Cg3_192 A:105 VSS 5.60298e-19
Cg3_193 A:107 VSS 2.38246e-19
Cg3_194 A:108 VSS 9.99012e-20
Cg3_195 A:110 VSS 9.8281e-19
Cg3_196 A:112 VSS 2.37676e-19
Cg3_197 A:113 VSS 6.32666e-19
Cg3_198 A:115 VSS 7.88992e-20
Cg3_199 A:117 VSS 7.39304e-20
Cg3_200 A:119 VSS 7.39304e-20
Cg3_201 A:121 VSS 7.39304e-20
Cg3_202 A:123 VSS 7.39304e-20
Cg3_203 A:125 VSS 7.39304e-20
Cg3_204 A:127 VSS 7.39304e-20
Cg3_205 A:129 VSS 7.39304e-20
Cg3_206 A:131 VSS 7.39304e-20
Cg3_207 A:133 VSS 7.39304e-20
Cg3_208 A:135 VSS 7.39304e-20
Cg3_209 A:137 VSS 7.39304e-20
Cg3_210 A:139 VSS 7.39304e-20
Cg3_211 A:141 VSS 7.39304e-20
Cg3_212 A:144 VSS 2.25353e-18
Cg3_213 A:145 VSS 5.45777e-18
Cg3_214 A:146 VSS 2.26157e-18
R3_1 A A:114 12.5416
R3_2 A A:144 27.5916
R3_3 A A:146 29.4429
R3_4 M1:GATE A:109 7.57576
R3_5 M1:GATE A:108 7.57576
R3_6 M10:GATE A:64 7.57576
R3_7 M10:GATE A:63 7.57576
R3_8 M11:GATE A:59 7.57576
R3_9 M11:GATE A:58 7.57576
R3_10 M12:GATE A:54 7.57576
R3_11 M12:GATE A:53 7.57576
R3_12 M13:GATE A:49 7.57576
R3_13 M13:GATE A:48 7.57576
R3_14 M14:GATE A:44 7.57576
R3_15 M14:GATE A:43 7.57576
R3_16 M15:GATE A:39 7.57576
R3_17 M15:GATE A:38 7.57576
R3_18 M16:GATE A:35 7.57576
R3_19 M16:GATE A:34 7.57576
R3_20 M17:GATE A:111 7.57576
R3_21 M17:GATE A:110 7.57576
R3_22 M18:GATE A:106 7.57576
R3_23 M18:GATE A:105 7.57576
R3_24 M19:GATE A:101 7.57576
R3_25 M19:GATE A:100 7.57576
R3_26 M2:GATE A:104 7.57576
R3_27 M2:GATE A:103 7.57576
R3_28 M20:GATE A:96 7.57576
R3_29 M20:GATE A:95 7.57576
R3_30 M21:GATE A:91 7.57576
R3_31 M21:GATE A:90 7.57576
R3_32 M22:GATE A:86 7.57576
R3_33 M22:GATE A:85 7.57576
R3_34 M23:GATE A:81 7.57576
R3_35 M23:GATE A:80 7.57576
R3_36 M24:GATE A:76 7.57576
R3_37 M24:GATE A:75 7.57576
R3_38 M25:GATE A:71 7.57576
R3_39 M25:GATE A:70 7.57576
R3_40 M26:GATE A:66 7.57576
R3_41 M26:GATE A:65 7.57576
R3_42 M27:GATE A:61 7.57576
R3_43 M27:GATE A:60 7.57576
R3_44 M28:GATE A:56 7.57576
R3_45 M28:GATE A:55 7.57576
R3_46 M29:GATE A:51 7.57576
R3_47 M29:GATE A:50 7.57576
R3_48 M3:GATE A:99 7.57576
R3_49 M3:GATE A:98 7.57576
R3_50 M30:GATE A:46 7.57576
R3_51 M30:GATE A:45 7.57576
R3_52 M31:GATE A:41 7.57576
R3_53 M31:GATE A:40 7.57576
R3_54 M32:GATE A:37 13.1313
R3_55 M32:GATE A:36 7.57576
R3_56 M4:GATE A:94 7.57576
R3_57 M4:GATE A:93 7.57576
R3_58 M5:GATE A:89 7.57576
R3_59 M5:GATE A:88 7.57576
R3_60 M6:GATE A:84 7.57576
R3_61 M6:GATE A:83 7.57576
R3_62 M7:GATE A:79 7.57576
R3_63 M7:GATE A:78 7.57576
R3_64 M8:GATE A:74 7.57576
R3_65 M8:GATE A:73 7.57576
R3_66 M9:GATE A:69 7.57576
R3_67 M9:GATE A:68 7.57576
R3_68 A:34 A:147 5.55556
R3_69 A:35 A:115 10.6061
R3_70 A:36 A:115 10.6061
R3_71 A:38 A:148 5.55556
R3_72 A:39 A:117 10.6061
R3_73 A:40 A:117 10.6061
R3_74 A:41 A:42 5.55556
R3_75 A:43 A:149 5.55556
R3_76 A:44 A:119 10.6061
R3_77 A:45 A:119 10.6061
R3_78 A:46 A:47 5.55556
R3_79 A:48 A:150 5.55556
R3_80 A:49 A:121 10.6061
R3_81 A:50 A:121 10.6061
R3_82 A:51 A:52 5.55556
R3_83 A:53 A:151 5.55556
R3_84 A:54 A:123 10.6061
R3_85 A:55 A:123 10.6061
R3_86 A:56 A:57 5.55556
R3_87 A:58 A:152 5.55556
R3_88 A:59 A:125 10.6061
R3_89 A:60 A:125 10.6061
R3_90 A:61 A:62 5.55556
R3_91 A:63 A:153 5.55556
R3_92 A:64 A:127 10.6061
R3_93 A:65 A:127 10.6061
R3_94 A:66 A:67 5.55556
R3_95 A:68 A:154 5.55556
R3_96 A:69 A:129 10.6061
R3_97 A:70 A:129 10.6061
R3_98 A:71 A:72 5.55556
R3_99 A:73 A:155 5.55556
R3_100 A:74 A:131 10.6061
R3_101 A:75 A:131 10.6061
R3_102 A:76 A:77 5.55556
R3_103 A:78 A:156 5.55556
R3_104 A:79 A:133 10.6061
R3_105 A:80 A:133 10.6061
R3_106 A:81 A:82 5.55556
R3_107 A:83 A:157 5.55556
R3_108 A:84 A:135 10.6061
R3_109 A:85 A:135 10.6061
R3_110 A:86 A:87 5.55556
R3_111 A:88 A:158 5.55556
R3_112 A:89 A:137 10.6061
R3_113 A:90 A:137 10.6061
R3_114 A:91 A:92 5.55556
R3_115 A:93 A:159 5.55556
R3_116 A:94 A:139 10.6061
R3_117 A:95 A:139 10.6061
R3_118 A:96 A:97 5.55556
R3_119 A:98 A:160 5.55556
R3_120 A:99 A:141 10.6061
R3_121 A:100 A:141 10.6061
R3_122 A:101 A:102 5.55556
R3_123 A:103 A:161 5.55556
R3_124 A:104 A:113 10.6061
R3_125 A:105 A:113 10.6061
R3_126 A:106 A:107 5.55556
R3_127 A:108 A:162 5.55556
R3_128 A:109 A:163 10.6061
R3_129 A:110 A:163 10.6061
R3_130 A:111 A:112 5.55556
R3_131 A:113 A:143 27.7339
R3_132 A:114 A:115 63.5281
R3_133 A:114 A:116 25.0832
R3_134 A:116 A:117 63.5281
R3_135 A:116 A:118 25.0832
R3_136 A:118 A:119 63.5281
R3_137 A:118 A:120 25.0832
R3_138 A:120 A:121 63.5281
R3_139 A:120 A:122 25.0832
R3_140 A:122 A:123 63.5281
R3_141 A:122 A:124 25.0832
R3_142 A:124 A:125 63.5281
R3_143 A:124 A:126 25.0832
R3_144 A:126 A:127 63.5281
R3_145 A:126 A:128 25.0832
R3_146 A:128 A:129 63.5281
R3_147 A:128 A:130 25.0832
R3_148 A:130 A:131 63.5281
R3_149 A:130 A:132 25.0832
R3_150 A:132 A:133 63.5281
R3_151 A:132 A:134 25.0832
R3_152 A:134 A:135 63.5281
R3_153 A:134 A:136 25.0832
R3_154 A:136 A:137 63.5281
R3_155 A:136 A:138 25.0832
R3_156 A:138 A:139 63.5281
R3_157 A:138 A:140 25.0832
R3_158 A:140 A:141 63.5281
R3_159 A:140 A:142 37.6249
R3_160 A:142 A:143 63.5281
R3_161 A:142 A:145 3.58332
R3_162 A:143 A:163 27.7339

*|NET Y 0.000260409PF
*|P (Y B 0 0.6930 0.0720)
*|I (M1:SRC M1 SRC B 0 0.6660 0.0360)
*|I (M10:DRN M10 DRN B 0 0.3000 0.0360)
*|I (M11:SRC M11 SRC B 0 0.2460 0.0360)
*|I (M12:DRN M12 DRN B 0 0.2160 0.0360)
*|I (M13:SRC M13 SRC B 0 0.1620 0.0360)
*|I (M14:DRN M14 DRN B 0 0.1320 0.0360)
*|I (M15:SRC M15 SRC B 0 0.0780 0.0360)
*|I (M16:DRN M16 DRN B 0 0.0480 0.0360)
*|I (M17:SRC M17 SRC B 0 0.6660 0.1080)
*|I (M18:DRN M18 DRN B 0 0.6360 0.1080)
*|I (M19:SRC M19 SRC B 0 0.5820 0.1080)
*|I (M2:DRN M2 DRN B 0 0.6360 0.0360)
*|I (M20:DRN M20 DRN B 0 0.5520 0.1080)
*|I (M21:SRC M21 SRC B 0 0.4980 0.1080)
*|I (M22:DRN M22 DRN B 0 0.4680 0.1080)
*|I (M23:SRC M23 SRC B 0 0.4140 0.1080)
*|I (M24:DRN M24 DRN B 0 0.3840 0.1080)
*|I (M25:SRC M25 SRC B 0 0.3300 0.1080)
*|I (M26:DRN M26 DRN B 0 0.3000 0.1080)
*|I (M27:SRC M27 SRC B 0 0.2460 0.1080)
*|I (M28:DRN M28 DRN B 0 0.2160 0.1080)
*|I (M29:SRC M29 SRC B 0 0.1620 0.1080)
*|I (M3:SRC M3 SRC B 0 0.5820 0.0360)
*|I (M30:DRN M30 DRN B 0 0.1320 0.1080)
*|I (M31:SRC M31 SRC B 0 0.0780 0.1080)
*|I (M32:DRN M32 DRN B 0 0.0480 0.1080)
*|I (M4:DRN M4 DRN B 0 0.5520 0.0360)
*|I (M5:SRC M5 SRC B 0 0.4980 0.0360)
*|I (M6:DRN M6 DRN B 0 0.4680 0.0360)
*|I (M7:SRC M7 SRC B 0 0.4140 0.0360)
*|I (M8:DRN M8 DRN B 0 0.3840 0.0360)
*|I (M9:SRC M9 SRC B 0 0.3300 0.0360)
C4_1 M16:DRN VSS:18 2.82443e-20
C4_2 Y:98 VSS:18 3.02844e-20
C4_3 Y:99 VSS:18 3.02844e-20
C4_4 M14:DRN VSS:19 3.18486e-20
C4_5 Y:98 VSS:19 1.07171e-19
C4_6 Y:99 VSS:19 1.07171e-19
C4_7 M12:DRN VSS:20 3.18486e-20
C4_8 Y:98 VSS:20 6.77398e-20
C4_9 Y:99 VSS:20 6.77398e-20
C4_10 M10:DRN VSS:21 3.18486e-20
C4_11 Y:98 VSS:21 9.57002e-20
C4_12 Y:99 VSS:21 9.57002e-20
C4_13 M8:DRN VSS:22 3.18486e-20
C4_14 Y:98 VSS:22 1.07171e-19
C4_15 Y:99 VSS:22 1.07171e-19
C4_16 M6:DRN VSS:23 3.18486e-20
C4_17 Y:98 VSS:23 7.53871e-20
C4_18 Y:99 VSS:23 7.53871e-20
C4_19 M4:DRN VSS:24 3.18486e-20
C4_20 Y:98 VSS:24 1.03348e-19
C4_21 Y:99 VSS:24 1.03348e-19
C4_22 M2:DRN VSS:25 3.18486e-20
C4_23 Y:98 VSS:25 1.07171e-19
C4_24 Y:99 VSS:25 1.07171e-19
C4_25 Y:98 VSS:26 5.31152e-20
C4_26 Y:99 VSS:26 2.37724e-19
C4_27 M10:DRN VSS:35 2.08949e-20
C4_28 M12:DRN VSS:35 2.08949e-20
C4_29 M14:DRN VSS:35 2.08949e-20
C4_30 M16:DRN VSS:35 2.09115e-20
C4_31 M2:DRN VSS:35 2.08949e-20
C4_32 M4:DRN VSS:35 2.08949e-20
C4_33 M6:DRN VSS:35 2.08949e-20
C4_34 M8:DRN VSS:35 2.08949e-20
C4_35 Y:34 VSS:35 2.32212e-18
C4_36 Y:36 VSS:35 2.31904e-18
C4_37 Y:38 VSS:35 2.31904e-18
C4_38 Y:40 VSS:35 2.31904e-18
C4_39 Y:42 VSS:35 2.31904e-18
C4_40 Y:44 VSS:35 2.31904e-18
C4_41 Y:46 VSS:35 2.31904e-18
C4_42 Y:48 VSS:35 2.31904e-18
C4_43 Y:98 VSS:35 1.23745e-18
C4_44 Y:99 VSS:35 1.75119e-18
C4_45 Y:100 VSS:35 7.1223e-20
C4_46 Y:101 VSS:35 7.1223e-20
C4_47 Y:34 VSS:37 2.80042e-20
C4_48 Y:50 VSS:37 3.18486e-20
C4_49 Y:98 VSS:37 2.24176e-20
C4_50 Y:99 VSS:37 2.24176e-20
C4_51 Y:36 VSS:38 2.80042e-20
C4_52 Y:52 VSS:38 3.18486e-20
C4_53 Y:98 VSS:38 2.63409e-20
C4_54 Y:99 VSS:38 2.63409e-20
C4_55 Y:38 VSS:39 2.80042e-20
C4_56 Y:54 VSS:39 3.18486e-20
C4_57 Y:98 VSS:39 2.63409e-20
C4_58 Y:99 VSS:39 2.63409e-20
C4_59 Y:40 VSS:40 2.80042e-20
C4_60 Y:56 VSS:40 3.18486e-20
C4_61 Y:98 VSS:40 2.10392e-20
C4_62 Y:99 VSS:40 2.10392e-20
C4_63 Y:42 VSS:41 2.80042e-20
C4_64 Y:58 VSS:41 3.18486e-20
C4_65 Y:98 VSS:41 2.63409e-20
C4_66 Y:99 VSS:41 2.63409e-20
C4_67 Y:44 VSS:42 2.80042e-20
C4_68 Y:60 VSS:42 3.18486e-20
C4_69 Y:98 VSS:42 2.63409e-20
C4_70 Y:99 VSS:42 2.63409e-20
C4_71 Y:46 VSS:43 3.37061e-20
C4_72 Y:62 VSS:43 3.18486e-20
C4_73 Y:98 VSS:43 2.29478e-20
C4_74 Y:99 VSS:43 2.29478e-20
C4_75 Y:48 VSS:44 4.41381e-20
C4_76 Y:64 VSS:44 3.18486e-20
C4_77 Y:98 VSS:44 2.05167e-20
C4_78 Y:99 VSS:44 4.3239e-20
C4_79 Y:34 VSS:45 7.15914e-20
C4_80 Y:36 VSS:45 4.88444e-20
C4_81 Y:38 VSS:45 2.73966e-20
C4_82 Y:40 VSS:45 6.48362e-20
C4_83 Y:42 VSS:45 4.28239e-20
C4_84 Y:44 VSS:45 8.08279e-20
C4_85 Y:46 VSS:45 5.88157e-20
C4_86 Y:48 VSS:45 3.68035e-20
C4_87 Y:98 VSS:45 2.12883e-17
C4_88 Y:99 VSS:45 3.7577e-20
C4_89 Y:100 VSS:45 1.57133e-20
C4_90 Y:34 VSS:46 7.15914e-20
C4_91 Y:36 VSS:46 4.88444e-20
C4_92 Y:38 VSS:46 2.73966e-20
C4_93 Y:40 VSS:46 6.48362e-20
C4_94 Y:42 VSS:46 4.28239e-20
C4_95 Y:44 VSS:46 8.08279e-20
C4_96 Y:46 VSS:46 5.88157e-20
C4_97 Y:48 VSS:46 3.68035e-20
C4_98 Y:99 VSS:46 2.13258e-17
C4_99 Y:101 VSS:46 1.57133e-20
C4_100 M2:DRN VSS:47 1.38606e-19
C4_101 Y:98 VSS:47 2.0686e-19
C4_102 Y:99 VSS:47 2.0686e-19
C4_103 M4:DRN VSS:48 2.80042e-20
C4_104 Y:98 VSS:48 1.9069e-19
C4_105 Y:99 VSS:48 1.9069e-19
C4_106 M6:DRN VSS:49 2.80042e-20
C4_107 Y:98 VSS:49 3.42339e-19
C4_108 Y:99 VSS:49 3.42339e-19
C4_109 M8:DRN VSS:50 2.80042e-20
C4_110 Y:98 VSS:50 2.13195e-19
C4_111 Y:99 VSS:50 2.13195e-19
C4_112 M10:DRN VSS:51 2.80042e-20
C4_113 Y:98 VSS:51 2.32166e-19
C4_114 Y:99 VSS:51 2.32166e-19
C4_115 M12:DRN VSS:52 2.80042e-20
C4_116 Y:98 VSS:52 3.83815e-19
C4_117 Y:99 VSS:52 3.83815e-19
C4_118 M14:DRN VSS:53 2.80042e-20
C4_119 Y:98 VSS:53 2.01952e-19
C4_120 Y:99 VSS:53 2.01952e-19
C4_121 M16:DRN VSS:54 2.13821e-20
C4_122 Y:98 VSS:54 3.26865e-20
C4_123 Y:99 VSS:54 3.26865e-20
C4_124 M32:DRN VDD:18 2.82443e-20
C4_125 Y:100 VDD:18 3.01233e-20
C4_126 Y:101 VDD:18 3.01233e-20
C4_127 M30:DRN VDD:19 3.18808e-20
C4_128 Y:100 VDD:19 1.07104e-19
C4_129 Y:101 VDD:19 1.07104e-19
C4_130 M28:DRN VDD:20 3.18808e-20
C4_131 Y:100 VDD:20 6.76458e-20
C4_132 Y:101 VDD:20 6.76458e-20
C4_133 M26:DRN VDD:21 3.18808e-20
C4_134 Y:100 VDD:21 9.56255e-20
C4_135 Y:101 VDD:21 9.56255e-20
C4_136 M24:DRN VDD:22 3.18808e-20
C4_137 Y:100 VDD:22 1.07104e-19
C4_138 Y:101 VDD:22 1.07104e-19
C4_139 M22:DRN VDD:23 3.18808e-20
C4_140 Y:100 VDD:23 7.52983e-20
C4_141 Y:101 VDD:23 7.52983e-20
C4_142 M20:DRN VDD:24 3.18808e-20
C4_143 Y:100 VDD:24 1.03278e-19
C4_144 Y:101 VDD:24 1.03278e-19
C4_145 M18:DRN VDD:25 3.18808e-20
C4_146 Y:100 VDD:25 1.07104e-19
C4_147 Y:101 VDD:25 1.07104e-19
C4_148 Y:99 VDD:26 1.85749e-19
C4_149 Y:100 VDD:26 5.31118e-20
C4_150 Y:101 VDD:26 5.31118e-20
C4_151 M32:DRN VDD:28 2.13821e-20
C4_152 Y:100 VDD:28 3.26865e-20
C4_153 Y:101 VDD:28 3.26865e-20
C4_154 M30:DRN VDD:30 2.80634e-20
C4_155 Y:100 VDD:30 2.01957e-19
C4_156 Y:101 VDD:30 2.01957e-19
C4_157 M28:DRN VDD:32 2.80634e-20
C4_158 Y:100 VDD:32 3.83829e-19
C4_159 Y:101 VDD:32 3.83829e-19
C4_160 M26:DRN VDD:34 2.80634e-20
C4_161 Y:100 VDD:34 2.32173e-19
C4_162 Y:101 VDD:34 2.32173e-19
C4_163 M24:DRN VDD:35 2.80634e-20
C4_164 Y:100 VDD:35 2.13201e-19
C4_165 Y:101 VDD:35 2.13201e-19
C4_166 M22:DRN VDD:37 2.80634e-20
C4_167 Y:100 VDD:37 3.42351e-19
C4_168 Y:101 VDD:37 3.42351e-19
C4_169 M20:DRN VDD:39 2.80634e-20
C4_170 Y:100 VDD:39 1.90694e-19
C4_171 Y:101 VDD:39 1.90694e-19
C4_172 M18:DRN VDD:41 4.95842e-20
C4_173 Y:100 VDD:41 1.97633e-19
C4_174 Y:101 VDD:41 1.97633e-19
C4_175 Y:35 VDD:43 1.19561e-18
C4_176 Y:37 VDD:43 1.19561e-18
C4_177 Y:39 VDD:43 1.19561e-18
C4_178 Y:41 VDD:43 1.19561e-18
C4_179 Y:43 VDD:43 1.19561e-18
C4_180 Y:45 VDD:43 1.19561e-18
C4_181 Y:47 VDD:43 1.19561e-18
C4_182 Y:49 VDD:43 1.19561e-18
C4_183 Y:99 VDD:43 2.1059e-19
C4_184 Y:100 VDD:43 1.80304e-19
C4_185 Y:101 VDD:43 1.80304e-19
C4_186 Y:35 VDD:45 2.80634e-20
C4_187 Y:51 VDD:45 3.18808e-20
C4_188 Y:100 VDD:45 2.24198e-20
C4_189 Y:101 VDD:45 2.24198e-20
C4_190 Y:37 VDD:46 2.80634e-20
C4_191 Y:53 VDD:46 3.18808e-20
C4_192 Y:100 VDD:46 2.63492e-20
C4_193 Y:101 VDD:46 2.63492e-20
C4_194 Y:39 VDD:47 2.80634e-20
C4_195 Y:55 VDD:47 3.18808e-20
C4_196 Y:100 VDD:47 2.63492e-20
C4_197 Y:101 VDD:47 2.63492e-20
C4_198 Y:41 VDD:48 2.80634e-20
C4_199 Y:57 VDD:48 3.18808e-20
C4_200 Y:100 VDD:48 2.10392e-20
C4_201 Y:101 VDD:48 2.10392e-20
C4_202 Y:43 VDD:49 2.80634e-20
C4_203 Y:59 VDD:49 3.18808e-20
C4_204 Y:100 VDD:49 2.63492e-20
C4_205 Y:101 VDD:49 2.63492e-20
C4_206 Y:45 VDD:50 2.80634e-20
C4_207 Y:61 VDD:50 3.18808e-20
C4_208 Y:100 VDD:50 2.63492e-20
C4_209 Y:101 VDD:50 2.63492e-20
C4_210 Y:47 VDD:51 2.80634e-20
C4_211 Y:63 VDD:51 3.18808e-20
C4_212 Y:100 VDD:51 2.29508e-20
C4_213 Y:101 VDD:51 2.29508e-20
C4_214 Y:49 VDD:52 4.41973e-20
C4_215 Y:65 VDD:52 3.18808e-20
C4_216 Y:99 VDD:52 2.28626e-20
C4_217 Y:100 VDD:52 2.05167e-20
C4_218 Y:101 VDD:52 2.05167e-20
C4_219 Y:35 VDD:53 1.28193e-19
C4_220 Y:37 VDD:53 1.05506e-19
C4_221 Y:39 VDD:53 8.41185e-20
C4_222 Y:41 VDD:53 1.21453e-19
C4_223 Y:43 VDD:53 9.95027e-20
C4_224 Y:45 VDD:53 1.374e-19
C4_225 Y:47 VDD:53 1.1545e-19
C4_226 Y:49 VDD:53 9.34991e-20
C4_227 Y:98 VDD:53 1.57277e-20
C4_228 Y:99 VDD:53 3.7647e-20
C4_229 Y:100 VDD:53 2.13872e-17
C4_230 Y:35 VDD:54 1.28193e-19
C4_231 Y:37 VDD:54 1.05506e-19
C4_232 Y:39 VDD:54 8.41185e-20
C4_233 Y:41 VDD:54 1.21453e-19
C4_234 Y:43 VDD:54 9.95027e-20
C4_235 Y:45 VDD:54 1.374e-19
C4_236 Y:47 VDD:54 1.1545e-19
C4_237 Y:49 VDD:54 9.34991e-20
C4_238 Y:99 VDD:54 5.33746e-20
C4_239 Y:101 VDD:54 2.13872e-17
C4_240 Y:34 A 1.50604e-19
C4_241 Y:35 A 2.98336e-20
C4_242 Y:36 A 1.50129e-19
C4_243 Y:37 A 2.93607e-20
C4_244 Y:38 A 1.50129e-19
C4_245 Y:39 A 2.93607e-20
C4_246 Y:40 A 1.50129e-19
C4_247 Y:41 A 2.93607e-20
C4_248 Y:42 A 1.50129e-19
C4_249 Y:43 A 2.93607e-20
C4_250 Y:44 A 1.50129e-19
C4_251 Y:45 A 2.93607e-20
C4_252 Y:46 A 1.50129e-19
C4_253 Y:47 A 2.93607e-20
C4_254 Y:48 A 1.80155e-19
C4_255 Y:49 A 9.90114e-20
C4_256 Y:98 A 1.14232e-17
C4_257 Y:99 A 4.25295e-19
C4_258 Y:100 A 1.13999e-17
C4_259 Y:98 A:38 1.35017e-20
C4_260 Y:99 A:38 1.35017e-20
C4_261 Y:98 A:39 2.7549e-20
C4_262 Y:99 A:39 2.7549e-20
C4_263 Y:100 A:41 2.75551e-20
C4_264 Y:101 A:41 2.75551e-20
C4_265 Y:100 A:42 9.06385e-21
C4_266 Y:101 A:42 9.06385e-21
C4_267 Y:98 A:43 1.41074e-20
C4_268 Y:99 A:43 1.41074e-20
C4_269 Y:98 A:44 3.06445e-20
C4_270 Y:99 A:44 3.06445e-20
C4_271 Y:100 A:46 3.06522e-20
C4_272 Y:101 A:46 3.06522e-20
C4_273 Y:100 A:47 9.66748e-21
C4_274 Y:101 A:47 9.66748e-21
C4_275 Y:98 A:48 1.41074e-20
C4_276 Y:99 A:48 1.41074e-20
C4_277 Y:98 A:49 3.06445e-20
C4_278 Y:99 A:49 3.06445e-20
C4_279 Y:100 A:51 3.06522e-20
C4_280 Y:101 A:51 3.06522e-20
C4_281 Y:100 A:52 9.66748e-21
C4_282 Y:101 A:52 9.66748e-21
C4_283 Y:98 A:53 1.28959e-20
C4_284 Y:99 A:53 1.28959e-20
C4_285 Y:98 A:54 2.44534e-20
C4_286 Y:99 A:54 2.44534e-20
C4_287 Y:100 A:56 2.4458e-20
C4_288 Y:101 A:56 2.4458e-20
C4_289 Y:100 A:57 8.46023e-21
C4_290 Y:101 A:57 8.46023e-21
C4_291 Y:98 A:58 1.73631e-20
C4_292 Y:99 A:58 1.73631e-20
C4_293 Y:98 A:59 4.72831e-20
C4_294 Y:99 A:59 4.72831e-20
C4_295 Y:100 A:61 4.72989e-20
C4_296 Y:101 A:61 4.72989e-20
C4_297 Y:100 A:62 1.2912e-20
C4_298 Y:101 A:62 1.2912e-20
C4_299 Y:98 A:63 1.41074e-20
C4_300 Y:99 A:63 1.41074e-20
C4_301 Y:98 A:64 3.06445e-20
C4_302 Y:99 A:64 3.06445e-20
C4_303 Y:100 A:66 3.06522e-20
C4_304 Y:101 A:66 3.06522e-20
C4_305 Y:100 A:67 9.66748e-21
C4_306 Y:101 A:67 9.66748e-21
C4_307 Y:98 A:68 1.41074e-20
C4_308 Y:99 A:68 1.41074e-20
C4_309 Y:98 A:69 3.06445e-20
C4_310 Y:99 A:69 3.06445e-20
C4_311 Y:100 A:71 3.06522e-20
C4_312 Y:101 A:71 3.06522e-20
C4_313 Y:100 A:72 9.66748e-21
C4_314 Y:101 A:72 9.66748e-21
C4_315 Y:98 A:73 1.85745e-20
C4_316 Y:99 A:73 1.85745e-20
C4_317 Y:98 A:74 5.34741e-20
C4_318 Y:99 A:74 5.34741e-20
C4_319 Y:100 A:76 5.34931e-20
C4_320 Y:101 A:76 5.34931e-20
C4_321 Y:100 A:77 1.41192e-20
C4_322 Y:101 A:77 1.41192e-20
C4_323 Y:98 A:78 1.41074e-20
C4_324 Y:99 A:78 1.41074e-20
C4_325 Y:98 A:79 3.06445e-20
C4_326 Y:99 A:79 3.06445e-20
C4_327 Y:100 A:81 3.06522e-20
C4_328 Y:101 A:81 3.06522e-20
C4_329 Y:100 A:82 9.66748e-21
C4_330 Y:101 A:82 9.66748e-21
C4_331 Y:98 A:83 1.41074e-20
C4_332 Y:99 A:83 1.41074e-20
C4_333 Y:98 A:84 3.06445e-20
C4_334 Y:99 A:84 3.06445e-20
C4_335 Y:100 A:86 3.06522e-20
C4_336 Y:101 A:86 3.06522e-20
C4_337 Y:100 A:87 9.66748e-21
C4_338 Y:101 A:87 9.66748e-21
C4_339 Y:98 A:88 1.75145e-20
C4_340 Y:99 A:88 1.75145e-20
C4_341 Y:98 A:89 4.80569e-20
C4_342 Y:99 A:89 4.80569e-20
C4_343 Y:100 A:91 4.80732e-20
C4_344 Y:101 A:91 4.80732e-20
C4_345 Y:100 A:92 1.30629e-20
C4_346 Y:101 A:92 1.30629e-20
C4_347 Y:98 A:93 1.41074e-20
C4_348 Y:99 A:93 1.41074e-20
C4_349 Y:98 A:94 3.06445e-20
C4_350 Y:99 A:94 3.06445e-20
C4_351 Y:100 A:96 3.06522e-20
C4_352 Y:101 A:96 3.06522e-20
C4_353 Y:100 A:97 9.66748e-21
C4_354 Y:101 A:97 9.66748e-21
C4_355 Y:98 A:98 4.98178e-21
C4_356 Y:99 A:98 4.98178e-21
C4_357 Y:46 A:99 6.91052e-19
C4_358 Y:62 A:99 1.23247e-18
C4_359 Y:98 A:99 3.15604e-20
C4_360 Y:99 A:99 3.15604e-20
C4_361 Y:46 A:100 1.87735e-19
C4_362 Y:47 A:100 1.87735e-19
C4_363 Y:98 A:100 3.65988e-20
C4_364 Y:99 A:100 3.65988e-20
C4_365 Y:100 A:100 1.77341e-20
C4_366 Y:101 A:100 1.77341e-20
C4_367 Y:100 A:101 2.37759e-20
C4_368 Y:101 A:101 2.37759e-20
C4_369 Y:100 A:102 9.66748e-21
C4_370 Y:101 A:102 9.66748e-21
C4_371 Y:98 A:104 2.56177e-20
C4_372 Y:99 A:104 2.56177e-20
C4_373 Y:98 A:105 3.65988e-20
C4_374 Y:99 A:105 8.02756e-20
C4_375 Y:100 A:105 3.66396e-20
C4_376 Y:101 A:105 3.66396e-20
C4_377 Y:100 A:106 2.61434e-20
C4_378 Y:101 A:106 2.61434e-20
C4_379 Y:100 A:107 1.57038e-20
C4_380 Y:101 A:107 1.57038e-20
C4_381 Y:48 A:108 1.82222e-19
C4_382 Y:48 A:109 6.85177e-19
C4_383 Y:64 A:109 1.22701e-18
C4_384 Y:98 A:109 2.94342e-20
C4_385 Y:99 A:109 1.60328e-19
C4_386 Y:48 A:110 1.83539e-19
C4_387 Y:49 A:110 1.83539e-19
C4_388 Y:99 A:110 2.47161e-19
C4_389 Y:49 A:111 6.85193e-19
C4_390 Y:65 A:111 1.22717e-18
C4_391 Y:99 A:111 1.31702e-19
C4_392 Y:100 A:111 2.94497e-20
C4_393 Y:101 A:111 2.94497e-20
C4_394 Y:49 A:112 1.82222e-19
C4_395 M18:DRN A:113 2.09115e-20
C4_396 Y:48 A:113 1.17406e-18
C4_397 Y:49 A:113 2.33954e-18
C4_398 Y:99 A:113 2.14361e-19
C4_399 Y:100 A:113 5.84763e-20
C4_400 Y:101 A:113 5.84763e-20
C4_401 Y:100 A:117 1.30724e-20
C4_402 Y:101 A:117 1.30724e-20
C4_403 Y:100 A:119 1.30724e-20
C4_404 Y:101 A:119 1.30724e-20
C4_405 Y:100 A:121 1.30724e-20
C4_406 Y:101 A:121 1.30724e-20
C4_407 Y:100 A:123 1.30724e-20
C4_408 Y:101 A:123 1.30724e-20
C4_409 Y:100 A:125 1.30724e-20
C4_410 Y:101 A:125 1.30724e-20
C4_411 Y:100 A:127 1.30724e-20
C4_412 Y:101 A:127 1.30724e-20
C4_413 Y:100 A:129 1.30724e-20
C4_414 Y:101 A:129 1.30724e-20
C4_415 Y:100 A:131 1.30724e-20
C4_416 Y:101 A:131 1.30724e-20
C4_417 Y:100 A:133 1.30724e-20
C4_418 Y:101 A:133 1.30724e-20
C4_419 Y:100 A:135 1.30724e-20
C4_420 Y:101 A:135 1.30724e-20
C4_421 Y:100 A:137 1.30724e-20
C4_422 Y:101 A:137 1.30724e-20
C4_423 Y:100 A:139 1.30724e-20
C4_424 Y:101 A:139 1.30724e-20
C4_425 Y:100 A:141 1.30724e-20
C4_426 Y:101 A:141 1.30724e-20
C4_427 Y:98 A:144 4.78131e-19
C4_428 Y:99 A:144 5.9316e-19
C4_429 Y:34 A:145 1.50604e-19
C4_430 Y:35 A:145 2.98336e-20
C4_431 Y:36 A:145 1.50129e-19
C4_432 Y:37 A:145 2.93607e-20
C4_433 Y:38 A:145 1.50129e-19
C4_434 Y:39 A:145 2.93607e-20
C4_435 Y:40 A:145 1.50129e-19
C4_436 Y:41 A:145 2.93607e-20
C4_437 Y:42 A:145 1.50129e-19
C4_438 Y:43 A:145 2.93607e-20
C4_439 Y:44 A:145 1.50129e-19
C4_440 Y:45 A:145 2.93607e-20
C4_441 Y:46 A:145 1.50129e-19
C4_442 Y:47 A:145 2.93607e-20
C4_443 Y:48 A:145 1.80155e-19
C4_444 Y:49 A:145 9.90114e-20
C4_445 Y:99 A:145 1.18485e-17
C4_446 Y:101 A:145 1.13999e-17
C4_447 Y:99 A:146 1.19601e-19
C4_448 Y:100 A:146 4.9676e-19
C4_449 Y:101 A:146 4.9676e-19
Cg4_450 Y:34 VSS 4.11852e-19
Cg4_451 Y:35 VSS 3.60318e-19
Cg4_452 Y:36 VSS 4.11852e-19
Cg4_453 Y:37 VSS 3.60318e-19
Cg4_454 Y:38 VSS 4.11852e-19
Cg4_455 Y:39 VSS 3.60318e-19
Cg4_456 Y:40 VSS 4.11852e-19
Cg4_457 Y:41 VSS 3.60318e-19
Cg4_458 Y:42 VSS 4.11852e-19
Cg4_459 Y:43 VSS 3.60318e-19
Cg4_460 Y:44 VSS 4.11852e-19
Cg4_461 Y:45 VSS 3.60318e-19
Cg4_462 Y:46 VSS 4.04337e-19
Cg4_463 Y:47 VSS 3.60318e-19
Cg4_464 Y:48 VSS 3.06377e-19
Cg4_465 Y:49 VSS 2.97398e-19
Cg4_466 Y:50 VSS 2.67377e-19
Cg4_467 Y:51 VSS 2.67634e-19
Cg4_468 Y:52 VSS 2.67377e-19
Cg4_469 Y:53 VSS 2.67634e-19
Cg4_470 Y:54 VSS 2.67377e-19
Cg4_471 Y:55 VSS 2.67634e-19
Cg4_472 Y:56 VSS 2.67377e-19
Cg4_473 Y:57 VSS 2.67634e-19
Cg4_474 Y:58 VSS 2.67377e-19
Cg4_475 Y:59 VSS 2.67634e-19
Cg4_476 Y:60 VSS 2.67377e-19
Cg4_477 Y:61 VSS 2.67634e-19
Cg4_478 Y:62 VSS 2.67377e-19
Cg4_479 Y:63 VSS 2.67634e-19
Cg4_480 Y:64 VSS 2.20595e-19
Cg4_481 Y:65 VSS 2.20434e-19
Cg4_482 Y:98 VSS 3.98351e-18
Cg4_483 Y:99 VSS 6.42606e-18
Cg4_484 Y:100 VSS 3.97783e-18
Cg4_485 Y:101 VSS 3.97783e-18
R4_1 Y Y:101 25.8596
R4_2 Y Y:99 25.7999
R4_3 M1:SRC Y:64 30000.0
R4_4 M1:SRC Y:116 20270.3
R4_5 M1:SRC Y:48 57692.3
R4_6 M1:SRC Y:95 30000.0
R4_7 M10:DRN Y:56 30000.0
R4_8 M10:DRN Y:108 20270.3
R4_9 M10:DRN Y:40 57692.3
R4_10 M10:DRN Y:79 30000.0
R4_11 M11:SRC Y:54 30000.0
R4_12 M11:SRC Y:106 20270.3
R4_13 M11:SRC Y:38 57692.3
R4_14 M11:SRC Y:75 30000.0
R4_15 M12:DRN Y:54 30000.0
R4_16 M12:DRN Y:106 20270.3
R4_17 M12:DRN Y:38 57692.3
R4_18 M12:DRN Y:75 30000.0
R4_19 M13:SRC Y:52 30000.0
R4_20 M13:SRC Y:104 20270.3
R4_21 M13:SRC Y:36 57692.3
R4_22 M13:SRC Y:71 30000.0
R4_23 M14:DRN Y:52 30000.0
R4_24 M14:DRN Y:104 20270.3
R4_25 M14:DRN Y:36 57692.3
R4_26 M14:DRN Y:71 30000.0
R4_27 M15:SRC Y:50 30000.0
R4_28 M15:SRC Y:102 20270.3
R4_29 M15:SRC Y:34 57692.3
R4_30 M15:SRC Y:67 30000.0
R4_31 M16:DRN Y:50 30000.0
R4_32 M16:DRN Y:102 20270.3
R4_33 M16:DRN Y:34 57692.3
R4_34 M16:DRN Y:67 30000.0
R4_35 M17:SRC Y:49 30000.0
R4_36 M17:SRC Y:117 20089.3
R4_37 M17:SRC Y:65 59210.5
R4_38 M17:SRC Y:97 30000.0
R4_39 M18:DRN Y:49 30000.0
R4_40 M18:DRN Y:117 20089.3
R4_41 M18:DRN Y:65 59210.5
R4_42 M18:DRN Y:97 30000.0
R4_43 M19:SRC Y:47 30000.0
R4_44 M19:SRC Y:115 20089.3
R4_45 M19:SRC Y:63 59210.5
R4_46 M19:SRC Y:93 30000.0
R4_47 M2:DRN Y:64 30000.0
R4_48 M2:DRN Y:116 20270.3
R4_49 M2:DRN Y:48 57692.3
R4_50 M2:DRN Y:95 30000.0
R4_51 M20:DRN Y:47 30000.0
R4_52 M20:DRN Y:115 20089.3
R4_53 M20:DRN Y:63 59210.5
R4_54 M20:DRN Y:93 30000.0
R4_55 M21:SRC Y:45 30000.0
R4_56 M21:SRC Y:113 20089.3
R4_57 M21:SRC Y:61 59210.5
R4_58 M21:SRC Y:89 30000.0
R4_59 M22:DRN Y:45 30000.0
R4_60 M22:DRN Y:113 20089.3
R4_61 M22:DRN Y:61 59210.5
R4_62 M22:DRN Y:89 30000.0
R4_63 M23:SRC Y:43 30000.0
R4_64 M23:SRC Y:111 20089.3
R4_65 M23:SRC Y:59 59210.5
R4_66 M23:SRC Y:85 30000.0
R4_67 M24:DRN Y:43 30000.0
R4_68 M24:DRN Y:111 20089.3
R4_69 M24:DRN Y:59 59210.5
R4_70 M24:DRN Y:85 30000.0
R4_71 M25:SRC Y:41 30000.0
R4_72 M25:SRC Y:109 20089.3
R4_73 M25:SRC Y:57 59210.5
R4_74 M25:SRC Y:81 30000.0
R4_75 M26:DRN Y:41 30000.0
R4_76 M26:DRN Y:109 20089.3
R4_77 M26:DRN Y:57 59210.5
R4_78 M26:DRN Y:81 30000.0
R4_79 M27:SRC Y:39 30000.0
R4_80 M27:SRC Y:107 20089.3
R4_81 M27:SRC Y:55 59210.5
R4_82 M27:SRC Y:77 30000.0
R4_83 M28:DRN Y:39 30000.0
R4_84 M28:DRN Y:107 20089.3
R4_85 M28:DRN Y:55 59210.5
R4_86 M28:DRN Y:77 30000.0
R4_87 M29:SRC Y:37 30000.0
R4_88 M29:SRC Y:105 20089.3
R4_89 M29:SRC Y:53 59210.5
R4_90 M29:SRC Y:73 30000.0
R4_91 M3:SRC Y:62 30000.0
R4_92 M3:SRC Y:114 20270.3
R4_93 M3:SRC Y:46 57692.3
R4_94 M3:SRC Y:91 30000.0
R4_95 M30:DRN Y:37 30000.0
R4_96 M30:DRN Y:105 20089.3
R4_97 M30:DRN Y:53 59210.5
R4_98 M30:DRN Y:73 30000.0
R4_99 M31:SRC Y:35 30000.0
R4_100 M31:SRC Y:103 20089.3
R4_101 M31:SRC Y:51 59210.5
R4_102 M31:SRC Y:69 30000.0
R4_103 M32:DRN Y:35 30000.0
R4_104 M32:DRN Y:103 20089.3
R4_105 M32:DRN Y:51 59210.5
R4_106 M32:DRN Y:69 30000.0
R4_107 M4:DRN Y:62 30000.0
R4_108 M4:DRN Y:114 20270.3
R4_109 M4:DRN Y:46 57692.3
R4_110 M4:DRN Y:91 30000.0
R4_111 M5:SRC Y:60 30000.0
R4_112 M5:SRC Y:112 20270.3
R4_113 M5:SRC Y:44 57692.3
R4_114 M5:SRC Y:87 30000.0
R4_115 M6:DRN Y:60 30000.0
R4_116 M6:DRN Y:112 20270.3
R4_117 M6:DRN Y:44 57692.3
R4_118 M6:DRN Y:87 30000.0
R4_119 M7:SRC Y:58 30000.0
R4_120 M7:SRC Y:110 20270.3
R4_121 M7:SRC Y:42 57692.3
R4_122 M7:SRC Y:83 30000.0
R4_123 M8:DRN Y:58 30000.0
R4_124 M8:DRN Y:110 20270.3
R4_125 M8:DRN Y:42 57692.3
R4_126 M8:DRN Y:83 30000.0
R4_127 M9:SRC Y:56 30000.0
R4_128 M9:SRC Y:108 20270.3
R4_129 M9:SRC Y:40 57692.3
R4_130 M9:SRC Y:79 30000.0
R4_131 Y:34 Y:67 5.51634
R4_132 Y:35 Y:69 14.1199
R4_133 Y:35 Y:103 8.62446
R4_134 Y:36 Y:71 5.51634
R4_135 Y:37 Y:73 14.1199
R4_136 Y:37 Y:105 8.62446
R4_137 Y:38 Y:75 5.51634
R4_138 Y:39 Y:107 8.62446
R4_139 Y:39 Y:77 14.1199
R4_140 Y:40 Y:79 5.51634
R4_141 Y:41 Y:109 8.62446
R4_142 Y:41 Y:81 14.1199
R4_143 Y:42 Y:83 5.51634
R4_144 Y:43 Y:111 8.62446
R4_145 Y:43 Y:85 14.1199
R4_146 Y:44 Y:87 5.51634
R4_147 Y:45 Y:113 8.62446
R4_148 Y:45 Y:89 14.1199
R4_149 Y:46 Y:91 5.51634
R4_150 Y:47 Y:115 8.62446
R4_151 Y:47 Y:93 14.1199
R4_152 Y:48 Y:95 5.51634
R4_153 Y:49 Y:117 8.62446
R4_154 Y:49 Y:97 14.1199
R4_155 Y:50 Y:67 14.0605
R4_156 Y:50 Y:102 49500.0
R4_157 Y:51 Y:69 5.45702
R4_158 Y:52 Y:71 14.0605
R4_159 Y:52 Y:104 49500.0
R4_160 Y:53 Y:73 5.45702
R4_161 Y:54 Y:75 14.0605
R4_162 Y:54 Y:106 49500.0
R4_163 Y:55 Y:77 5.45702
R4_164 Y:56 Y:79 14.0605
R4_165 Y:56 Y:108 49500.0
R4_166 Y:57 Y:81 5.45702
R4_167 Y:58 Y:83 14.0605
R4_168 Y:58 Y:110 49500.0
R4_169 Y:59 Y:85 5.45702
R4_170 Y:60 Y:87 14.0605
R4_171 Y:60 Y:112 49500.0
R4_172 Y:61 Y:89 5.45702
R4_173 Y:62 Y:91 14.0605
R4_174 Y:62 Y:114 49500.0
R4_175 Y:63 Y:93 5.45702
R4_176 Y:64 Y:95 14.0605
R4_177 Y:64 Y:116 49500.0
R4_178 Y:65 Y:97 5.45702
R4_179 Y:66 Y:67 63.5281
R4_180 Y:66 Y:98 3.58332
R4_181 Y:66 Y:70 50.1665
R4_182 Y:67 Y:102 3.7634
R4_183 Y:68 Y:69 63.5281
R4_184 Y:68 Y:100 3.58332
R4_185 Y:68 Y:72 50.1665
R4_186 Y:69 Y:103 21900.0
R4_187 Y:70 Y:71 63.5281
R4_188 Y:70 Y:74 50.1665
R4_189 Y:71 Y:104 3.7634
R4_190 Y:72 Y:73 63.5281
R4_191 Y:72 Y:76 50.1665
R4_192 Y:73 Y:105 21900.0
R4_193 Y:74 Y:75 63.5281
R4_194 Y:74 Y:78 50.1665
R4_195 Y:75 Y:106 3.7634
R4_196 Y:76 Y:77 63.5281
R4_197 Y:76 Y:80 50.1665
R4_198 Y:77 Y:107 21900.0
R4_199 Y:78 Y:79 63.5281
R4_200 Y:78 Y:82 50.1665
R4_201 Y:79 Y:108 3.7634
R4_202 Y:80 Y:81 63.5281
R4_203 Y:80 Y:84 50.1665
R4_204 Y:81 Y:109 21900.0
R4_205 Y:82 Y:83 63.5281
R4_206 Y:82 Y:86 50.1665
R4_207 Y:83 Y:110 3.7634
R4_208 Y:84 Y:85 63.5281
R4_209 Y:84 Y:88 50.1665
R4_210 Y:85 Y:111 21900.0
R4_211 Y:86 Y:87 63.5281
R4_212 Y:86 Y:90 50.1665
R4_213 Y:87 Y:112 3.7634
R4_214 Y:88 Y:89 63.5281
R4_215 Y:88 Y:92 50.1665
R4_216 Y:89 Y:113 21900.0
R4_217 Y:90 Y:91 63.5281
R4_218 Y:90 Y:94 50.1665
R4_219 Y:91 Y:114 3.7634
R4_220 Y:92 Y:93 63.5281
R4_221 Y:92 Y:96 50.1665
R4_222 Y:93 Y:115 21900.0
R4_223 Y:94 Y:95 63.5281
R4_224 Y:94 Y:99 25.0832
R4_225 Y:95 Y:116 3.7634
R4_226 Y:96 Y:97 63.5281
R4_227 Y:96 Y:101 25.0832
R4_228 Y:97 Y:117 21900.0

*|NET 6 0PF
R6_1 6:1 6:2 144455.0

*|NET 7 0.000164687PF
C7_1 7:1 VSS:18 8.03136e-19
C7_2 7:1 VSS:19 8.03382e-19
C7_3 7:1 VSS:20 8.03382e-19
C7_4 7:1 VSS:21 8.03382e-19
C7_5 7:1 VSS:22 8.03382e-19
C7_6 7:1 VSS:23 8.03382e-19
C7_7 7:1 VSS:24 8.03382e-19
C7_8 7:1 VSS:35 1.20021e-19
C7_9 7:3 VSS:35 1.35956e-19
C7_10 7:1 VSS:45 1.55941e-18
C7_11 7:2 VSS:45 2.77545e-19
C7_12 7:3 VSS:45 1.60099e-20
C7_13 7:1 VSS:46 1.55941e-18
C7_14 7:2 VSS:46 2.77545e-19
C7_15 7:3 VSS:46 1.60099e-20
C7_16 7:1 VSS:48 1.50868e-18
C7_17 7:1 VSS:49 1.50868e-18
C7_18 7:1 VSS:50 1.50868e-18
C7_19 7:1 VSS:51 1.50868e-18
C7_20 7:1 VSS:52 1.50868e-18
C7_21 7:1 VSS:53 1.50868e-18
C7_22 7:1 VSS:54 1.50136e-18
C7_23 7:1 VDD:18 8.0314e-19
C7_24 7:1 VDD:19 8.03418e-19
C7_25 7:1 VDD:20 8.03418e-19
C7_26 7:1 VDD:21 8.03418e-19
C7_27 7:1 VDD:22 8.03418e-19
C7_28 7:1 VDD:23 8.03418e-19
C7_29 7:1 VDD:24 8.03418e-19
C7_30 7:1 VDD:28 1.50126e-18
C7_31 7:1 VDD:30 1.50862e-18
C7_32 7:1 VDD:32 1.50862e-18
C7_33 7:1 VDD:34 1.50862e-18
C7_34 7:1 VDD:35 1.50862e-18
C7_35 7:1 VDD:37 1.50862e-18
C7_36 7:1 VDD:39 1.50862e-18
C7_37 7:1 VDD:41 3.47913e-19
C7_38 7:1 VDD:53 1.8898e-18
C7_39 7:1 VDD:54 1.8898e-18
C7_40 7:1 Y:34 1.07714e-18
C7_41 7:1 Y:35 1.07721e-18
C7_42 7:1 Y:36 1.07714e-18
C7_43 7:1 Y:37 1.07721e-18
C7_44 7:1 Y:38 1.07714e-18
C7_45 7:1 Y:39 1.07721e-18
C7_46 7:1 Y:40 1.07714e-18
C7_47 7:1 Y:41 1.07721e-18
C7_48 7:1 Y:42 1.07714e-18
C7_49 7:1 Y:43 1.07721e-18
C7_50 7:1 Y:44 1.07714e-18
C7_51 7:1 Y:45 1.07721e-18
C7_52 7:1 Y:46 1.0432e-20
C7_53 7:2 Y:46 1.80413e-19
C7_54 7:1 Y:47 8.89477e-19
C7_55 7:1 Y:50 8.03382e-19
C7_56 7:1 Y:51 8.03418e-19
C7_57 7:1 Y:52 8.03382e-19
C7_58 7:1 Y:53 8.03418e-19
C7_59 7:1 Y:54 8.03382e-19
C7_60 7:1 Y:55 8.03418e-19
C7_61 7:1 Y:56 8.03382e-19
C7_62 7:1 Y:57 8.03418e-19
C7_63 7:1 Y:58 8.03382e-19
C7_64 7:1 Y:59 8.03418e-19
C7_65 7:1 Y:60 8.03382e-19
C7_66 7:1 Y:61 8.03418e-19
C7_67 7:1 Y:63 8.03418e-19
C7_68 7:1 Y:98 1.6096e-18
C7_69 7:2 Y:98 9.07827e-20
C7_70 7:3 Y:98 3.99156e-20
C7_71 7:1 Y:99 2.07168e-18
C7_72 7:2 Y:99 9.07827e-20
C7_73 7:3 Y:99 1.1599e-19
C7_74 7:1 Y:100 1.73925e-18
C7_75 7:1 Y:101 1.73925e-18
Cg7_76 7:1 VSS 8.71024e-17
Cg7_77 7:2 VSS 3.96707e-18
R7_1 7:1 7:2 10289.6
R7_2 7:2 7:3 1326.22

*|NET _generated_10 5.37479e-06PF
C8_1 _generated_10:1 VSS:35 9.21148e-19
C8_2 _generated_10:1 VSS:45 4.84077e-20
C8_3 _generated_10:1 VSS:46 4.84077e-20
C8_4 _generated_10:1 A:105 7.90108e-21
C8_5 _generated_10:1 A:108 1.58022e-21
C8_6 _generated_10:1 A:110 2.39886e-19
Cg8_7 _generated_10:1 VSS 3.50331e-18
R8_1 _generated_10:1 _generated_10:2 28.2828

*|NET _generated_11 5.0073e-06PF
C9_1 _generated_11:1 VDD:43 5.78695e-19
C9_2 _generated_11:1 VDD:53 9.59123e-20
C9_3 _generated_11:1 VDD:54 9.59123e-20
C9_4 _generated_11:1 A:105 7.90108e-21
C9_5 _generated_11:1 A:110 2.39886e-19
C9_6 _generated_11:1 A:112 1.58022e-21
C9_7 _generated_11:1 _generated_10:1 6.0415e-19
Cg9_8 _generated_11:1 VSS 3.38326e-18
R9_1 _generated_11:1 _generated_11:2 28.2828

*|NET _generated_8 2.86348e-06PF
C10_1 _generated_8:1 VSS:45 1.12789e-20
C10_2 _generated_8:1 VSS:46 1.12789e-20
C10_3 _generated_8:1 VSS:54 3.44976e-19
C10_4 _generated_8:1 A:144 3.06042e-19
C10_5 _generated_8:1 7:1 6.61239e-19
Cg10_6 _generated_8:1 VSS 9.49624e-19
R10_1 _generated_8:1 _generated_8:2 28.2828

*|NET _generated_9 3.08088e-06PF
C11_1 _generated_9:1 VSS:35 1.47021e-19
C11_2 _generated_9:1 VDD:28 3.74453e-19
C11_3 _generated_9:1 VDD:43 1.18927e-19
C11_4 _generated_9:1 VDD:53 2.44946e-20
C11_5 _generated_9:1 VDD:54 2.44946e-20
C11_6 _generated_9:1 A:146 3.15962e-19
C11_7 _generated_9:1 7:1 5.65589e-19
C11_8 _generated_9:1 _generated_8:1 5.79044e-19
Cg11_9 _generated_9:1 VSS 9.3089e-19
R11_1 _generated_9:1 _generated_9:2 28.2828

*
* Instance Section
*
MM1 M1:DRN M1:GATE M1:SRC VSS NMOS_LVT l=0.012u w=0.03u NF=1
MM10 M10:DRN M10:GATE M10:SRC VSS NMOS_LVT l=0.012u w=0.03u NF=1
MM11 M11:DRN M11:GATE M11:SRC VSS NMOS_LVT l=0.012u w=0.03u NF=1
MM12 M12:DRN M12:GATE M12:SRC VSS NMOS_LVT l=0.012u w=0.03u NF=1
MM13 M13:DRN M13:GATE M13:SRC VSS NMOS_LVT l=0.012u w=0.03u NF=1
MM14 M14:DRN M14:GATE M14:SRC VSS NMOS_LVT l=0.012u w=0.03u NF=1
MM15 M15:DRN M15:GATE M15:SRC VSS NMOS_LVT l=0.012u w=0.03u NF=1
MM16 M16:DRN M16:GATE M16:SRC VSS NMOS_LVT l=0.012u w=0.03u NF=1
MM17 M17:DRN M17:GATE M17:SRC VDD PMOS_LVT l=0.012u w=0.03u NF=1
MM18 M18:DRN M18:GATE M18:SRC VDD PMOS_LVT l=0.012u w=0.03u NF=1
MM19 M19:DRN M19:GATE M19:SRC VDD PMOS_LVT l=0.012u w=0.03u NF=1
MM2 M2:DRN M2:GATE M2:SRC VSS NMOS_LVT l=0.012u w=0.03u NF=1
MM20 M20:DRN M20:GATE M20:SRC VDD PMOS_LVT l=0.012u w=0.03u NF=1
MM21 M21:DRN M21:GATE M21:SRC VDD PMOS_LVT l=0.012u w=0.03u NF=1
MM22 M22:DRN M22:GATE M22:SRC VDD PMOS_LVT l=0.012u w=0.03u NF=1
MM23 M23:DRN M23:GATE M23:SRC VDD PMOS_LVT l=0.012u w=0.03u NF=1
MM24 M24:DRN M24:GATE M24:SRC VDD PMOS_LVT l=0.012u w=0.03u NF=1
MM25 M25:DRN M25:GATE M25:SRC VDD PMOS_LVT l=0.012u w=0.03u NF=1
MM26 M26:DRN M26:GATE M26:SRC VDD PMOS_LVT l=0.012u w=0.03u NF=1
MM27 M27:DRN M27:GATE M27:SRC VDD PMOS_LVT l=0.012u w=0.03u NF=1
MM28 M28:DRN M28:GATE M28:SRC VDD PMOS_LVT l=0.012u w=0.03u NF=1
MM29 M29:DRN M29:GATE M29:SRC VDD PMOS_LVT l=0.012u w=0.03u NF=1
MM3 M3:DRN M3:GATE M3:SRC VSS NMOS_LVT l=0.012u w=0.03u NF=1
MM30 M30:DRN M30:GATE M30:SRC VDD PMOS_LVT l=0.012u w=0.03u NF=1
MM31 M31:DRN M31:GATE M31:SRC VDD PMOS_LVT l=0.012u w=0.03u NF=1
MM32 M32:DRN M32:GATE M32:SRC VDD PMOS_LVT l=0.012u w=0.03u NF=1
MM4 M4:DRN M4:GATE M4:SRC VSS NMOS_LVT l=0.012u w=0.03u NF=1
MM5 M5:DRN M5:GATE M5:SRC VSS NMOS_LVT l=0.012u w=0.03u NF=1
MM6 M6:DRN M6:GATE M6:SRC VSS NMOS_LVT l=0.012u w=0.03u NF=1
MM7 M7:DRN M7:GATE M7:SRC VSS NMOS_LVT l=0.012u w=0.03u NF=1
MM8 M8:DRN M8:GATE M8:SRC VSS NMOS_LVT l=0.012u w=0.03u NF=1
MM9 M9:DRN M9:GATE M9:SRC VSS NMOS_LVT l=0.012u w=0.03u NF=1

.ENDS
