* CANDIDATE independent circuit from preserved2024 prior-layout DSPF.
* All resistive segments collapsed to ideal wires; capacitors omitted for LVS topology.
* Not extracted from the new144nmDUT. Requires independent review before gold admission.
* Source /cedar/cedar_coe/ece-limsk/sw.jung/pdk/LIB_issue_fix/final_w17_pdk/1_fspr/10_liberate_final_fspr_rvt/NETLIST/AOI21x1.spf
.SUBCKT AOI21x1 A B C VDD VSS Y
MMM8 Y C VSS nmos_rvt l=0.012u w=0.03u
MMM10 Y B MM10:SRC nmos_rvt l=0.012u w=0.03u
MMM11 MM10:SRC A VSS nmos_rvt l=0.012u w=0.03u
MMM7 Y C MM3:DRN pmos_rvt l=0.012u w=0.03u
MMM4 MM3:DRN B VDD pmos_rvt l=0.012u w=0.03u
MMM3 MM3:DRN A VDD pmos_rvt l=0.012u w=0.03u
.ends AOI21x1
