*
*|DSPF 1.3
*|DESIGN AOI222x1
*|DATE "Tue Nov  3 21:33:26 2026"
*|VENDOR "Synopsys"
*|PROGRAM "StarRC"
*|VERSION "X-2025.06-SP1"
*|DIVIDER /
*|DELIMITER :
**FORMAT SPF
*

** COMMENTS

** OPERATING_TEMPERATURE 25
** GLOBAL_TEMPERATURE 25
**
** TCAD_GRD_FILE /cedar/cedar_coe/ece-limsk/yhuang861/GRO/.planning/experiments_migrated_20261022/usc144_github_release_20261103/sources/github_FSPR.nxtgrd
**   TCAD_TIME_STAMP Tue Mar 31 05:07:55 2026
**   TCADGRD_VERSION 89

.SUBCKT AOI222x1 VSS VDD Y A B C D E F

*|GROUND_NET VSS

*|NET VSS 0.000129319PF
*|P (VSS B 0 0.1680 0.0000)
*|I (M2:SRC M2 SRC B 0 0.2460 0.0360)
*|I (M3:DRN M3 DRN B 0 0.2160 0.0360)
*|I (M6:SRC M6 SRC B 0 0.0360 0.0360)
Cg1_1 VSS:5 VSS 2.52098e-19
Cg1_2 VSS:6 VSS 2.48443e-19
Cg1_3 VSS:17 VSS 3.00453e-18
Cg1_4 VSS:22 VSS 4.75959e-17
Cg1_5 VSS:25 VSS 4.67272e-18
Cg1_6 VSS:27 VSS 9.22225e-18
Cg1_7 VSS:28 VSS 5.2628e-19
R1_1 VSS VSS:14 12.5416
R1_2 VSS VSS:12 12.5416
R1_3 M2:SRC VSS:24 30000.0
R1_4 M2:SRC VSS:6 30000.0
R1_5 M2:SRC VSS:33 15000.0
R1_6 M3:DRN VSS:24 30000.0
R1_7 M3:DRN VSS:6 30000.0
R1_8 M3:DRN VSS:33 15000.0
R1_9 M6:SRC VSS:23 30000.0
R1_10 M6:SRC VSS:5 30000.0
R1_11 M6:SRC VSS:31 15000.0
R1_12 VSS:5 VSS:31 7.8411
R1_13 VSS:5 VSS:28 12.4587
R1_14 VSS:6 VSS:17 12.4587
R1_15 VSS:6 VSS:33 7.84041
R1_16 VSS:7 VSS:27 17.9166
R1_17 VSS:7 VSS:8 25.0832
R1_18 VSS:7 VSS:28 31.764
R1_19 VSS:8 VSS:9 63.5281
R1_20 VSS:8 VSS:10 25.0832
R1_21 VSS:9 VSS:28 50.1851
R1_22 VSS:9 VSS:11 55.4677
R1_23 VSS:10 VSS:11 63.5281
R1_24 VSS:10 VSS:12 25.0832
R1_25 VSS:11 VSS:13 55.4677
R1_26 VSS:12 VSS:13 63.5281
R1_27 VSS:13 VSS:15 55.4677
R1_28 VSS:14 VSS:15 63.5281
R1_29 VSS:14 VSS:16 25.0832
R1_30 VSS:15 VSS:17 50.1851
R1_31 VSS:16 VSS:17 31.764
R1_32 VSS:16 VSS:18 25.0832
R1_33 VSS:17 VSS:19 50.1851
R1_34 VSS:18 VSS:19 63.5281
R1_35 VSS:18 VSS:20 25.0832
R1_36 VSS:19 VSS:21 55.4677
R1_37 VSS:20 VSS:21 63.5281
R1_38 VSS:20 VSS:35 17.9166
R1_39 VSS:21 VSS:30 39.6198
R1_40 VSS:22 VSS:25 7778.54
R1_41 VSS:23 VSS:31 7.8411
R1_42 VSS:23 VSS:32 1.77981
R1_43 VSS:24 VSS:33 7.84041
R1_44 VSS:24 VSS:34 1.77981
R1_45 VSS:25 VSS:26 4070.12
R1_46 VSS:28 VSS:29 34.3372
R1_47 VSS:22 VSS:28 0.01

*|NET VDD 6.79514e-05PF
*|P (VDD B 0 0.1680 0.1440)
*|I (M11:DRN M11 DRN B 0 0.0900 0.1080)
*|I (M12:SRC M12 SRC B 0 0.0360 0.1080)
C2_1 VDD VSS:17 7.79004e-20
C2_2 VDD:10 VSS:17 3.83957e-20
C2_3 VDD:21 VSS:17 6.70874e-21
C2_4 VDD:24 VSS:17 6.38861e-20
C2_5 VDD VSS:22 1.92528e-18
C2_6 VDD:4 VSS:22 8.02895e-19
C2_7 VDD:24 VSS:22 1.49995e-18
C2_8 VDD VSS:27 8.63608e-19
C2_9 VDD:10 VSS:27 2.76282e-20
C2_10 VDD VSS:28 8.78916e-22
C2_11 VDD:21 VSS:28 3.86285e-21
C2_12 VDD:24 VSS:28 1.20446e-19
Cg2_13 VDD VSS 1.06463e-17
Cg2_14 VDD:4 VSS 2.76091e-19
Cg2_15 VDD:5 VSS 1.78742e-19
Cg2_16 VDD:10 VSS 1.72614e-17
Cg2_17 VDD:21 VSS 5.43919e-21
Cg2_18 VDD:23 VSS 5.43542e-21
Cg2_19 VDD:24 VSS 8.29438e-19
R2_1 VDD VDD:11 12.5416
R2_2 VDD VDD:13 12.5416
R2_3 VDD VDD:22 58595.5
R2_4 M11:DRN VDD:23 30000.0
R2_5 M11:DRN VDD:5 30000.0
R2_6 M11:DRN VDD:29 15000.0
R2_7 M12:SRC VDD:21 30000.0
R2_8 M12:SRC VDD:4 30000.0
R2_9 M12:SRC VDD:27 15000.0
R2_10 VDD:4 VDD:27 7.8411
R2_11 VDD:4 VDD:28 1.77981
R2_12 VDD:5 VDD:29 7.8411
R2_13 VDD:5 VDD:30 1.77981
R2_14 VDD:6 VDD:31 17.9166
R2_15 VDD:6 VDD:7 25.0832
R2_16 VDD:6 VDD:24 31.764
R2_17 VDD:7 VDD:8 63.5281
R2_18 VDD:7 VDD:9 25.0832
R2_19 VDD:8 VDD:24 50.1851
R2_20 VDD:8 VDD:10 50.1851
R2_21 VDD:9 VDD:10 31.764
R2_22 VDD:9 VDD:11 25.0832
R2_23 VDD:10 VDD:12 50.1851
R2_24 VDD:10 VDD:23 12.4587
R2_25 VDD:11 VDD:12 63.5281
R2_26 VDD:12 VDD:14 55.4677
R2_27 VDD:13 VDD:14 63.5281
R2_28 VDD:13 VDD:15 25.0832
R2_29 VDD:14 VDD:16 55.4677
R2_30 VDD:15 VDD:16 63.5281
R2_31 VDD:15 VDD:17 25.0832
R2_32 VDD:16 VDD:18 55.4677
R2_33 VDD:17 VDD:18 63.5281
R2_34 VDD:17 VDD:19 25.0832
R2_35 VDD:18 VDD:20 55.4677
R2_36 VDD:19 VDD:20 63.5281
R2_37 VDD:19 VDD:32 17.9166
R2_38 VDD:20 VDD:26 39.6198
R2_39 VDD:21 VDD:27 7.8411
R2_40 VDD:21 VDD:24 12.4587
R2_41 VDD:23 VDD:29 7.8411
R2_42 VDD:24 VDD:25 34.3372

*|NET Y 6.23102e-05PF
*|P (Y B 0 0.2730 0.0720)
*|I (M1:DRN M1 DRN B 0 0.3000 0.0360)
*|I (M4:SRC M4 SRC B 0 0.1620 0.0360)
*|I (M5:DRN M5 DRN B 0 0.0900 0.0360)
*|I (M7:SRC M7 SRC B 0 0.2880 0.1080)
*|I (M8:DRN M8 DRN B 0 0.2580 0.1080)
C3_1 Y:17 VSS:6 1.52093e-19
C3_2 Y:18 VSS:6 3.3655e-20
C3_3 M1:DRN VSS:17 1.74124e-20
C3_4 Y:8 VSS:17 2.32373e-18
C3_5 Y:12 VSS:17 5.85324e-20
C3_6 Y:17 VSS:17 1.2757e-18
C3_7 Y:18 VSS:17 4.2112e-20
C3_8 Y:20 VSS:17 5.6462e-18
C3_9 Y:12 VSS:22 8.0075e-19
C3_10 Y:17 VSS:22 6.93111e-19
C3_11 Y:18 VSS:22 2.17916e-19
C3_12 Y:20 VSS:22 9.58151e-19
C3_13 Y:17 VSS:24 5.26665e-20
C3_14 Y:17 VSS:25 1.2978e-19
C3_15 Y:17 VSS:26 1.31172e-19
C3_16 Y:8 VSS:27 1.21448e-19
C3_17 Y:17 VSS:27 1.23301e-17
C3_18 Y:18 VSS:27 5.05808e-20
C3_19 Y:20 VSS:27 1.95004e-19
C3_20 Y:7 VDD 1.76661e-19
C3_21 Y:17 VDD 5.15198e-20
C3_22 Y:18 VDD 1.25913e-19
C3_23 Y:7 VDD:10 1.21143e-18
C3_24 Y:20 VDD:10 6.06228e-19
C3_25 Y:20 VDD:23 3.37931e-20
Cg3_26 Y:7 VSS 4.1468e-19
Cg3_27 Y:8 VSS 3.02077e-19
Cg3_28 Y:9 VSS 2.63697e-19
Cg3_29 Y:10 VSS 1.78742e-19
Cg3_30 Y:12 VSS 2.5234e-19
Cg3_31 Y:17 VSS 3.23409e-18
Cg3_32 Y:18 VSS 1.02511e-18
Cg3_33 Y:20 VSS 1.22171e-18
R3_1 Y Y:13 8.65969
R3_2 Y Y:17 25.7999
R3_3 M1:DRN Y:10 30000.0
R3_4 M1:DRN Y:22 20270.3
R3_5 M1:DRN Y:8 57692.3
R3_6 M1:DRN Y:16 30000.0
R3_7 M4:SRC Y:12 7500.0
R3_8 M5:DRN Y:20 7500.0
R3_9 M7:SRC Y:9 30000.0
R3_10 M7:SRC Y:7 30000.0
R3_11 M7:SRC Y:21 15000.0
R3_12 M8:DRN Y:9 30000.0
R3_13 M8:DRN Y:7 30000.0
R3_14 M8:DRN Y:21 15000.0
R3_15 Y:7 Y:9 18.6881
R3_16 Y:7 Y:14 3.85627
R3_17 Y:7 Y:21 7.84041
R3_18 Y:8 Y:16 5.51688
R3_19 Y:9 Y:21 49500.0
R3_20 Y:10 Y:16 14.0605
R3_21 Y:10 Y:22 98999.9
R3_22 Y:11 Y:12 63.5281
R3_23 Y:11 Y:23 3.58332
R3_24 Y:11 Y:17 75.2497
R3_25 Y:12 Y:20 9.75247
R3_26 Y:13 Y:14 63.5281
R3_27 Y:13 Y:18 5.9722
R3_28 Y:14 Y:19 5.04281
R3_29 Y:15 Y:16 63.5281
R3_30 Y:15 Y:17 25.0832
R3_31 Y:15 Y:24 3.58332
R3_32 Y:16 Y:22 3.76373

*|NET A 1.83529e-05PF
*|P (A B 0 0.0210 0.0720)
*|I (M12:GATE M12 GATE I 3.6e-19 0.0420 0.1080)
*|I (M6:GATE M6 GATE I 3.6e-19 0.0420 0.0360)
C4_1 A:10 VSS:5 2.33814e-19
C4_2 A:4 VSS:17 4.61602e-19
C4_3 A:5 VSS:17 7.89427e-21
C4_4 A:10 VSS:17 9.63817e-20
C4_5 A:10 VSS:22 9.49128e-19
C4_6 A:10 VSS:23 4.85975e-20
C4_7 A:4 VSS:27 2.75992e-20
C4_8 A:10 VSS:27 1.48087e-18
C4_9 A:8 VSS:28 9.16124e-19
C4_10 A:10 VSS:28 6.15563e-19
C4_11 A:4 VDD 4.02543e-21
C4_12 A:7 VDD 4.85422e-20
C4_13 A:8 VDD 2.83023e-20
C4_14 A:10 VDD 1.48871e-18
C4_15 A:10 VDD:4 1.1494e-19
C4_16 A:7 VDD:10 1.15802e-19
C4_17 A:8 VDD:21 1.48933e-20
C4_18 A:10 VDD:21 1.16593e-19
C4_19 A:8 VDD:24 1.58128e-18
C4_20 A:10 VDD:24 4.73109e-19
Cg4_21 A:4 VSS 1.09486e-19
Cg4_22 A:6 VSS 3.4119e-19
Cg4_23 A:7 VSS 2.31874e-19
Cg4_24 A:8 VSS 1.99342e-19
Cg4_25 A:10 VSS 3.57105e-18
R4_1 A A:10 29.3832
R4_2 A A:13 29.4429
R4_3 A A:9 63.5281
R4_4 M12:GATE A:7 13.1313
R4_5 M12:GATE A:6 7.57576
R4_6 M6:GATE A:5 7.57576
R4_7 M6:GATE A:4 7.57576
R4_8 A:4 A:11 5.55556
R4_9 A:5 A:8 10.6061
R4_10 A:6 A:8 10.6061
R4_11 A:8 A:9 27.7339
R4_12 A:9 A:12 7.92396

*|NET B 1.58152e-05PF
*|P (B B 0 0.0630 0.0720)
*|I (M11:GATE M11 GATE I 3.6e-19 0.0840 0.1080)
*|I (M5:GATE M5 GATE I 3.6e-19 0.0840 0.0360)
C5_1 B:11 VSS:5 8.37832e-20
C5_2 B:4 VSS:17 4.61602e-19
C5_3 B:5 VSS:17 7.89427e-21
C5_4 B:11 VSS:17 8.83916e-20
C5_5 B:11 VSS:22 3.84637e-19
C5_6 B:11 VSS:27 1.57773e-18
C5_7 B:11 VSS:28 1.07916e-19
C5_8 B:11 A:10 3.21551e-18
Cg5_9 B:4 VSS 1.09232e-19
Cg5_10 B:6 VSS 3.4119e-19
Cg5_11 B:8 VSS 3.84125e-19
Cg5_12 B:9 VSS 1.90311e-19
Cg5_13 B:11 VSS 1.79163e-18
R5_1 B B:11 29.3832
R5_2 B B:14 12.8402
R5_3 B B:10 63.5281
R5_4 M11:GATE B:7 7.57576
R5_5 M11:GATE B:6 7.57576
R5_6 M5:GATE B:5 7.57576
R5_7 M5:GATE B:4 7.57576
R5_8 B:4 B:12 5.55556
R5_9 B:5 B:9 10.6061
R5_10 B:6 B:9 10.6061
R5_11 B:7 B:8 5.55556
R5_12 B:9 B:10 27.7339
R5_13 B:10 B:13 7.92396

*|NET C 2.46739e-05PF
*|P (C B 0 0.1680 0.0575)
*|I (M10:GATE M10 GATE I 3.6e-19 0.1680 0.1080)
*|I (M4:GATE M4 GATE I 3.6e-19 0.1680 0.0360)
C6_1 C:4 VSS:17 4.59524e-19
C6_2 C:5 VSS:17 7.89427e-21
C6_3 C:10 VSS:17 9.87631e-20
C6_4 C VSS:22 8.55176e-20
C6_5 C:10 VSS:22 6.96353e-19
C6_6 C VSS:27 1.43286e-19
C6_7 C:10 VSS:27 2.21477e-18
C6_8 C Y:12 2.407e-20
C6_9 C:10 Y:12 1.62101e-20
C6_10 C Y:17 1.72404e-18
C6_11 C:4 Y:17 3.01833e-20
C6_12 C:5 Y:17 6.03687e-20
C6_13 C:10 Y:17 2.27052e-18
C6_14 C Y:18 2.54663e-20
C6_15 C:10 Y:18 5.58902e-20
C6_16 C Y:20 4.58007e-20
C6_17 C:10 Y:20 2.51548e-18
C6_18 C B:11 1.31365e-19
C6_19 C:10 B:11 2.05778e-18
Cg6_20 C VSS 7.33059e-19
Cg6_21 C:4 VSS 1.09775e-19
Cg6_22 C:6 VSS 3.4119e-19
Cg6_23 C:7 VSS 6.1397e-20
Cg6_24 C:8 VSS 4.05422e-19
Cg6_25 C:9 VSS 1.04259e-19
Cg6_26 C:10 VSS 1.80652e-18
R6_1 C C:9 63.5281
R6_2 C C:10 25.8463
R6_3 M10:GATE C:7 7.57576
R6_4 M10:GATE C:6 7.57576
R6_5 M4:GATE C:5 7.57576
R6_6 M4:GATE C:4 7.57576
R6_7 C:4 C:11 5.55556
R6_8 C:5 C:9 3.28283
R6_9 C:6 C:9 17.9293
R6_10 C:7 C:8 5.55556
R6_11 C:10 C:12 20.1263

*|NET D 1.44155e-05PF
*|P (D B 0 0.2170 0.0720)
*|I (M3:GATE M3 GATE I 3.6e-19 0.2100 0.0360)
*|I (M9:GATE M9 GATE I 3.6e-19 0.2100 0.1080)
C7_1 D:11 VSS:6 3.38457e-22
C7_2 D:4 VSS:17 4.59524e-19
C7_3 D:5 VSS:17 7.89427e-21
C7_4 D:9 VSS:17 1.05749e-19
C7_5 D:11 VSS:17 1.29447e-19
C7_6 D:11 VSS:22 4.0584e-19
C7_7 D:11 VSS:24 4.05834e-21
C7_8 D:11 VSS:27 1.59353e-19
C7_9 D:4 Y:17 2.82147e-20
C7_10 D:5 Y:17 6.18862e-20
C7_11 D:11 Y:17 1.57943e-18
C7_12 D:11 Y:18 2.94596e-19
C7_13 D:11 C 3.22336e-19
C7_14 D:11 C:10 7.55337e-19
Cg7_15 D:4 VSS 1.09775e-19
Cg7_16 D:6 VSS 3.4119e-19
Cg7_17 D:8 VSS 3.84125e-19
Cg7_18 D:9 VSS 1.52936e-19
Cg7_19 D:11 VSS 9.29753e-19
R7_1 D D:11 12.8402
R7_2 D D:14 10.1527
R7_3 D D:10 63.5281
R7_4 M3:GATE D:5 7.57576
R7_5 M3:GATE D:4 7.57576
R7_6 M9:GATE D:7 7.57576
R7_7 M9:GATE D:6 7.57576
R7_8 D:4 D:12 5.55556
R7_9 D:5 D:9 10.6061
R7_10 D:6 D:9 10.6061
R7_11 D:7 D:8 5.55556
R7_12 D:9 D:10 9.24462
R7_13 D:10 D:13 7.92396

*|NET E 1.91613e-05PF
*|P (E B 0 0.2450 0.0720)
*|I (M2:GATE M2 GATE I 3.6e-19 0.2520 0.0360)
*|I (M8:GATE M8 GATE I 3.6e-19 0.2520 0.1080)
C8_1 E:5 VSS:6 1.22566e-18
C8_2 E:11 VSS:6 2.49034e-20
C8_3 E:4 VSS:17 4.59524e-19
C8_4 E:5 VSS:17 6.93945e-19
C8_5 E:6 VSS:17 1.84809e-19
C8_6 E:9 VSS:17 2.3794e-19
C8_7 E:11 VSS:17 2.61398e-19
C8_8 E:11 VSS:22 2.81541e-19
C8_9 E:11 VSS:24 4.05834e-21
C8_10 E:4 VSS:27 2.66955e-20
C8_11 E:11 VSS:27 1.34049e-19
C8_12 E:4 M1:DRN 1.72248e-20
C8_13 E:4 Y:17 1.67976e-20
C8_14 E:5 Y:17 6.0995e-20
C8_15 E:6 Y:17 5.5751e-20
C8_16 E:11 Y:17 1.5822e-18
C8_17 E:5 Y:18 9.0737e-20
C8_18 E:6 Y:18 1.13733e-19
C8_19 E:11 Y:18 3.54457e-18
C8_20 E:6 D:9 1.55509e-20
C8_21 E:9 D:9 7.70097e-19
C8_22 E:11 D:9 4.85297e-20
C8_23 E:11 D:11 3.36328e-18
Cg8_24 E:4 VSS 2.2068e-19
Cg8_25 E:6 VSS 3.4119e-19
Cg8_26 E:8 VSS 3.91381e-19
Cg8_27 E:9 VSS 1.09397e-19
Cg8_28 E:11 VSS 1.49703e-18
R8_1 E E:11 12.8402
R8_2 E E:14 12.8402
R8_3 E E:10 63.5281
R8_4 M2:GATE E:5 7.57576
R8_5 M2:GATE E:4 7.57576
R8_6 M8:GATE E:7 7.57576
R8_7 M8:GATE E:6 7.57576
R8_8 E:4 E:12 5.55556
R8_9 E:5 E:9 10.6061
R8_10 E:6 E:9 10.6061
R8_11 E:7 E:8 5.55556
R8_12 E:9 E:10 9.24462
R8_13 E:10 E:13 7.92396

*|NET F 1.77617e-05PF
*|P (F B 0 0.3150 0.0720)
*|I (M1:GATE M1 GATE I 3.6e-19 0.2940 0.0360)
*|I (M7:GATE M7 GATE I 3.6e-19 0.2940 0.1080)
C9_1 F:4 VSS:17 4.59918e-19
C9_2 F:5 VSS:17 7.89427e-21
C9_3 F:11 VSS:22 2.89588e-19
C9_4 F:11 VSS:26 4.24381e-20
C9_5 F:4 VSS:27 5.58437e-20
C9_6 F:11 VSS:27 1.38665e-19
C9_7 F:11 M1:DRN 7.01306e-22
C9_8 F:6 Y:7 4.65014e-19
C9_9 F:7 Y:7 6.87355e-19
C9_10 F:8 Y:7 1.82222e-19
C9_11 F:11 Y:7 6.67928e-20
C9_12 F:9 Y:8 8.30991e-19
C9_13 F:11 Y:8 3.75132e-19
C9_14 F:7 Y:9 1.22544e-18
C9_15 F:11 Y:9 1.53602e-20
C9_16 F:11 Y:10 5.15375e-21
C9_17 F:5 Y:17 6.90934e-20
C9_18 F:6 Y:17 1.1048e-19
C9_19 F:11 Y:17 1.59015e-18
C9_20 F:5 Y:18 1.22076e-19
C9_21 F:6 Y:18 1.60319e-19
C9_22 F:7 Y:18 3.77742e-20
C9_23 F:11 Y:18 2.04268e-18
C9_24 F:4 E:4 5.04592e-19
C9_25 F:11 E:11 2.49683e-19
Cg9_26 F:4 VSS 1.00945e-19
Cg9_27 F:6 VSS 9.8281e-19
Cg9_28 F:8 VSS 4.2322e-19
Cg9_29 F:9 VSS 5.76142e-19
Cg9_30 F:11 VSS 1.62965e-18
R9_1 F F:11 12.8402
R9_2 F F:14 12.8402
R9_3 F F:10 63.5281
R9_4 M1:GATE F:5 7.57576
R9_5 M1:GATE F:4 7.57576
R9_6 M7:GATE F:7 7.57576
R9_7 M7:GATE F:6 7.57576
R9_8 F:4 F:12 5.55556
R9_9 F:5 F:9 10.6061
R9_10 F:6 F:9 10.6061
R9_11 F:7 F:8 5.55556
R9_12 F:9 F:10 27.7339
R9_13 F:10 F:13 7.92396

*|NET 15 7.47153e-07PF
*|I (M5:SRC M5 SRC B 0 0.0780 0.0360)
*|I (M6:DRN M6 DRN B 0 0.0480 0.0360)
C11_1 M6:DRN VSS:5 2.82443e-20
C11_2 M6:DRN VSS:17 4.65606e-19
C11_3 M6:DRN VSS:27 1.25731e-19
C11_4 M6:DRN VSS:28 2.13821e-20
C11_5 M6:DRN B:11 1.06189e-19
R11_1 M5:SRC M6:DRN 15000.0

*|NET 16 7.4695e-07PF
*|I (M3:SRC M3 SRC B 0 0.2040 0.0360)
*|I (M4:DRN M4 DRN B 0 0.1740 0.0360)
C12_1 M4:DRN VSS:17 4.67272e-19
C12_2 M4:DRN VSS:27 4.98644e-20
C12_3 M4:DRN Y:12 2.82443e-20
C12_4 M4:DRN Y:17 1.10395e-19
C12_5 M4:DRN Y:20 2.29785e-20
Cg12_6 M4:DRN VSS 1.35262e-20
R12_1 M3:SRC M4:DRN 15000.0

*|NET 17 8.90089e-07PF
*|I (M1:SRC M1 SRC B 0 0.2880 0.0360)
*|I (M2:DRN M2 DRN B 0 0.2580 0.0360)
C13_1 M2:DRN VSS:6 3.00786e-20
C13_2 M2:DRN VSS:17 5.03172e-19
C13_3 M2:DRN VSS:27 1.12475e-19
C13_4 M2:DRN Y:17 9.47759e-20
C13_5 M2:DRN Y:18 1.49587e-19
R13_1 M1:SRC M2:DRN 15000.0

*|NET 4 4.24681e-05PF
*|I (M10:DRN M10 DRN B 0 0.1740 0.1080)
*|I (M11:SRC M11 SRC B 0 0.0780 0.1080)
*|I (M12:DRN M12 DRN B 0 0.0480 0.1080)
*|I (M9:SRC M9 SRC B 0 0.2040 0.1080)
C14_1 4:5 VSS:22 1.06302e-18
C14_2 4:6 VSS:22 1.34607e-18
C14_3 4:7 VSS:22 8.00235e-19
C14_4 4:8 VSS:22 8.00964e-19
C14_5 4:11 VSS:22 1.61119e-19
C14_6 4:13 VSS:22 2.17859e-19
C14_7 4:14 VSS:22 5.59676e-19
C14_8 4:11 VSS:27 1.15933e-19
C14_9 4:13 VSS:27 2.78767e-19
C14_10 4:14 VSS:27 1.13971e-19
C14_11 4:5 VDD 2.85435e-19
C14_12 4:6 VDD 1.94206e-19
C14_13 4:11 VDD 1.60728e-19
C14_14 4:13 VDD 4.14226e-18
C14_15 4:14 VDD 9.19393e-19
C14_16 M12:DRN VDD:4 2.82443e-20
C14_17 4:13 VDD:4 5.97423e-20
C14_18 4:13 VDD:5 1.25386e-19
C14_19 4:14 VDD:5 1.47599e-19
C14_20 4:5 VDD:10 1.19561e-18
C14_21 4:6 VDD:10 1.21143e-18
C14_22 4:13 VDD:10 2.88564e-19
C14_23 4:14 VDD:10 2.18712e-19
C14_24 4:5 VDD:23 2.48114e-20
C14_25 4:7 VDD:23 3.01108e-20
C14_26 4:13 VDD:23 3.10128e-20
C14_27 4:14 VDD:23 3.36494e-20
C14_28 M12:DRN VDD:24 2.13821e-20
C14_29 4:13 VDD:24 6.48621e-20
C14_30 4:11 A:10 1.48018e-20
C14_31 4:13 A:10 9.31521e-19
C14_32 4:14 A:10 2.92355e-19
C14_33 4:13 B:4 3.17204e-21
C14_34 4:13 B:6 1.04891e-19
C14_35 4:13 B:7 8.30522e-20
C14_36 4:13 B:8 2.82385e-20
C14_37 M12:DRN B:9 1.71316e-20
C14_38 4:5 B:9 1.6205e-18
C14_39 4:13 B:9 7.77742e-20
C14_40 4:5 B:11 1.03448e-19
C14_41 4:11 B:11 8.28596e-20
C14_42 4:13 B:11 1.68759e-18
C14_43 4:14 B:11 9.6731e-19
C14_44 4:14 C 1.82956e-18
C14_45 4:14 C:6 9.10339e-20
C14_46 4:14 C:7 1.2639e-21
C14_47 4:14 C:10 5.27784e-18
C14_48 4:6 D:11 6.95509e-20
C14_49 4:8 D:11 3.11192e-21
C14_50 4:11 D:11 6.51333e-19
C14_51 4:14 D:11 1.29591e-18
C14_52 4:11 M4:DRN 3.92507e-20
C14_53 4:14 M4:DRN 1.54193e-20
Cg14_54 4:5 VSS 3.1714e-19
Cg14_55 4:6 VSS 4.42443e-19
Cg14_56 4:7 VSS 2.31761e-19
Cg14_57 4:8 VSS 2.72828e-19
Cg14_58 4:11 VSS 1.39163e-18
Cg14_59 4:13 VSS 8.10311e-19
Cg14_60 4:14 VSS 1.8067e-18
R14_1 M10:DRN 4:8 30000.0
R14_2 M10:DRN 4:6 30000.0
R14_3 M10:DRN 4:17 15000.0
R14_4 M11:SRC 4:5 30000.0
R14_5 M11:SRC 4:16 20089.3
R14_6 M11:SRC 4:7 59210.5
R14_7 M11:SRC 4:10 30000.0
R14_8 M12:DRN 4:5 30000.0
R14_9 M12:DRN 4:16 20089.3
R14_10 M12:DRN 4:7 59210.5
R14_11 M12:DRN 4:10 30000.0
R14_12 M9:SRC 4:8 30000.0
R14_13 M9:SRC 4:6 30000.0
R14_14 M9:SRC 4:17 15000.0
R14_15 4:5 4:16 8.62446
R14_16 4:5 4:10 14.1199
R14_17 4:6 4:8 18.6881
R14_18 4:6 4:12 3.85627
R14_19 4:6 4:17 7.84041
R14_20 4:7 4:10 5.45702
R14_21 4:8 4:17 49500.0
R14_22 4:9 4:10 63.5281
R14_23 4:9 4:18 3.58332
R14_24 4:9 4:13 25.0832
R14_25 4:10 4:16 21900.0
R14_26 4:11 4:12 63.5281
R14_27 4:11 4:14 41.6676
R14_28 4:12 4:15 5.04281
R14_29 4:13 4:14 16.6027

*|NET 6 4.64911e-05PF
*|I (M10:SRC M10 SRC B 0 0.1620 0.1080)
*|I (M7:DRN M7 DRN B 0 0.3000 0.1080)
*|I (M8:SRC M8 SRC B 0 0.2460 0.1080)
*|I (M9:DRN M9 DRN B 0 0.2160 0.1080)
C15_1 M9:DRN VSS:17 1.44921e-20
C15_2 6:6 VSS:17 3.61325e-19
C15_3 6:17 VSS:17 2.5355e-20
C15_4 6:5 VSS:22 1.06171e-18
C15_5 6:6 VSS:22 8.81404e-19
C15_6 6:8 VSS:22 8.00541e-19
C15_7 6:9 VSS:22 8.02071e-19
C15_8 6:17 VSS:22 1.07338e-18
C15_9 6:17 VSS:27 4.29036e-20
C15_10 6:5 VDD 2.70247e-19
C15_11 6:6 VDD 2.36152e-19
C15_12 6:7 VDD 2.3157e-19
C15_13 6:17 VDD 1.24659e-17
C15_14 6:5 VDD:10 1.4613e-18
C15_15 6:6 VDD:10 1.19561e-18
C15_16 6:7 VDD:10 1.06277e-18
C15_17 6:6 M8:DRN 2.48114e-20
C15_18 6:9 M8:DRN 3.01108e-20
C15_19 6:17 M8:DRN 4.42793e-20
C15_20 M7:DRN Y:7 3.58669e-20
C15_21 6:17 Y:7 4.16777e-19
C15_22 M7:DRN Y:8 3.52036e-21
C15_23 6:7 Y:8 1.21861e-19
C15_24 M7:DRN Y:9 2.91454e-20
C15_25 6:17 Y:9 2.07194e-19
C15_26 6:17 Y:17 9.2941e-19
C15_27 6:6 Y:18 2.21642e-20
C15_28 6:9 Y:18 1.77132e-20
C15_29 6:17 Y:18 1.78598e-18
C15_30 M10:SRC Y:20 2.85906e-20
C15_31 6:5 Y:20 5.70116e-19
C15_32 6:17 D:7 6.28728e-20
C15_33 6:17 D:8 1.9335e-20
C15_34 M9:DRN D:9 4.84896e-21
C15_35 6:6 D:9 5.39767e-19
C15_36 6:17 D:9 2.56853e-20
C15_37 6:6 D:11 2.45646e-20
C15_38 6:9 D:11 7.16711e-37
C15_39 6:17 D:11 1.28929e-18
C15_40 6:6 E:6 1.84809e-19
C15_41 6:17 E:6 2.98072e-20
C15_42 6:17 E:7 4.53924e-20
C15_43 6:17 E:8 1.85804e-20
C15_44 M9:DRN E:9 4.83811e-21
C15_45 6:6 E:9 5.38693e-19
C15_46 6:17 E:9 2.45388e-20
C15_47 M9:DRN E:11 4.05834e-21
C15_48 6:6 E:11 1.61598e-19
C15_49 6:9 E:11 3.79336e-20
C15_50 6:17 E:11 1.58309e-18
C15_51 6:17 F:6 1.1044e-19
C15_52 6:17 F:7 7.07495e-20
C15_53 6:17 F:8 3.14075e-20
C15_54 M7:DRN F:9 1.45522e-20
C15_55 6:7 F:9 1.63028e-18
C15_56 6:17 F:9 5.95675e-20
C15_57 M7:DRN F:11 7.01306e-22
C15_58 6:7 F:11 1.13363e-19
C15_59 6:10 F:11 5.15375e-21
C15_60 6:17 F:11 1.58146e-18
C15_61 6:5 M10:DRN 2.48114e-20
C15_62 6:8 M10:DRN 3.01108e-20
C15_63 6:17 M10:DRN 5.15988e-20
C15_64 M9:DRN 4:6 2.30376e-20
C15_65 6:17 4:6 3.2441e-19
C15_66 M9:DRN 4:8 2.91454e-20
C15_67 6:17 4:8 2.20561e-19
C15_68 6:5 4:11 2.0906e-20
C15_69 6:8 4:11 1.71858e-20
C15_70 6:17 4:11 1.67222e-18
C15_71 6:17 4:13 1.16505e-18
C15_72 M10:SRC 4:14 1.18268e-20
C15_73 6:5 4:14 2.1217e-19
C15_74 6:8 4:14 1.45968e-20
C15_75 6:17 4:14 3.22902e-18
Cg15_76 M10:SRC VSS 5.43542e-21
Cg15_77 6:5 VSS 3.83833e-19
Cg15_78 6:6 VSS 3.14693e-19
Cg15_79 6:7 VSS 2.84742e-19
Cg15_80 6:8 VSS 2.43988e-19
Cg15_81 6:9 VSS 2.27146e-19
Cg15_82 6:10 VSS 1.78742e-19
Cg15_83 6:17 VSS 2.51087e-18
R15_1 M10:SRC 6:5 30000.0
R15_2 M10:SRC 6:18 20089.3
R15_3 M10:SRC 6:8 59210.5
R15_4 M10:SRC 6:12 30000.0
R15_5 M7:DRN 6:7 30000.0
R15_6 M7:DRN 6:20 20089.3
R15_7 M7:DRN 6:10 59210.5
R15_8 M7:DRN 6:16 30000.0
R15_9 M8:SRC 6:6 30000.0
R15_10 M8:SRC 6:19 20089.3
R15_11 M8:SRC 6:9 59210.5
R15_12 M8:SRC 6:14 30000.0
R15_13 M9:DRN 6:6 30000.0
R15_14 M9:DRN 6:19 20089.3
R15_15 M9:DRN 6:14 30000.0
R15_16 M9:DRN 6:9 59210.5
R15_17 6:5 6:12 14.1199
R15_18 6:5 6:18 8.62521
R15_19 6:6 6:14 14.1199
R15_20 6:6 6:19 8.62446
R15_21 6:7 6:16 14.1199
R15_22 6:7 6:20 8.62521
R15_23 6:8 6:12 5.45756
R15_24 6:9 6:14 5.45702
R15_25 6:10 6:16 5.45756
R15_26 6:11 6:12 63.5281
R15_27 6:11 6:17 3.58332
R15_28 6:11 6:13 50.1665
R15_29 6:12 6:18 43800.0
R15_30 6:13 6:14 63.5281
R15_31 6:13 6:15 50.1665
R15_32 6:14 6:19 21900.0
R15_33 6:15 6:16 63.5281
R15_34 6:15 6:21 3.58332
R15_35 6:16 6:20 43800.0

*|NET _generated_18 2.86348e-06PF
C16_1 _generated_18:1 VSS:22 6.61239e-19
C16_2 _generated_18:1 VSS:27 2.25577e-20
C16_3 _generated_18:1 VSS:28 3.44976e-19
C16_4 _generated_18:1 A:10 3.06042e-19
Cg16_5 _generated_18:1 VSS 9.49624e-19
R16_1 _generated_18:1 _generated_18:2 28.2828

*|NET _generated_19 3.08088e-06PF
C17_1 _generated_19:1 VSS:17 1.47021e-19
C17_2 _generated_19:1 VSS:22 5.65589e-19
C17_3 _generated_19:1 VDD 4.89892e-20
C17_4 _generated_19:1 VDD:10 1.18927e-19
C17_5 _generated_19:1 VDD:24 3.74453e-19
C17_6 _generated_19:1 A:10 3.15962e-19
C17_7 _generated_19:1 _generated_18:1 5.79044e-19
Cg17_8 _generated_19:1 VSS 9.3089e-19
R17_1 _generated_19:1 _generated_19:2 28.2828

*|NET _generated_20 3.34062e-06PF
C18_1 _generated_20:1 VSS:22 8.36695e-19
C18_2 _generated_20:1 VSS:27 4.14718e-21
C18_3 _generated_20:1 Y:12 4.28044e-19
C18_4 _generated_20:1 Y:17 1.1825e-19
C18_5 _generated_20:1 C 1.18413e-20
C18_6 _generated_20:1 C:10 1.59756e-19
Cg18_7 _generated_20:1 VSS 1.21496e-18
R18_1 _generated_20:1 _generated_20:2 28.2828

*|NET _generated_21 3.35999e-06PF
C19_1 _generated_21:1 VSS:17 3.24803e-21
C19_2 _generated_21:1 VSS:22 5.94369e-19
C19_3 _generated_21:1 VDD 4.72708e-20
C19_4 _generated_21:1 VDD:10 1.17892e-19
C19_5 _generated_21:1 Y:20 1.79381e-19
C19_6 _generated_21:1 4:14 2.18976e-19
C19_7 _generated_21:1 6:5 3.52659e-19
C19_8 _generated_21:1 6:17 8.87957e-20
C19_9 _generated_21:1 _generated_20:1 5.66926e-19
Cg19_10 _generated_21:1 VSS 1.19047e-18
R19_1 _generated_21:1 _generated_21:2 28.2828

*|NET _generated_22 5.31922e-06PF
C20_1 _generated_22:1 VSS:17 4.61748e-19
C20_2 _generated_22:1 VSS:22 2.98844e-20
C20_3 _generated_22:1 VSS:27 8.26703e-20
C20_4 _generated_22:1 Y:8 3.81915e-19
C20_5 _generated_22:1 F:4 4.75026e-20
C20_6 _generated_22:1 F:6 2.39886e-19
C20_7 _generated_22:1 F:11 6.42481e-20
Cg20_8 _generated_22:1 VSS 3.40722e-18
R20_1 _generated_22:1 _generated_22:2 28.2828

*|NET _generated_23 4.96794e-06PF
C21_1 _generated_23:1 VDD 1.91825e-19
C21_2 _generated_23:1 VDD:10 1.19386e-19
C21_3 _generated_23:1 F:6 2.39886e-19
C21_4 _generated_23:1 F:8 4.75026e-20
C21_5 _generated_23:1 F:11 5.6875e-20
C21_6 _generated_23:1 6:7 3.81915e-19
C21_7 _generated_23:1 _generated_22:1 6.0415e-19
Cg21_8 _generated_23:1 VSS 3.3264e-18
R21_1 _generated_23:1 _generated_23:2 28.2828

*
* Instance Section
*
MM1 M1:DRN M1:GATE M1:SRC VSS NMOS_LVT l=0.012u w=0.03u NF=1
MM10 M10:DRN M10:GATE M10:SRC VDD PMOS_LVT l=0.012u w=0.03u NF=1
MM11 M11:DRN M11:GATE M11:SRC VDD PMOS_LVT l=0.012u w=0.03u NF=1
MM12 M12:DRN M12:GATE M12:SRC VDD PMOS_LVT l=0.012u w=0.03u NF=1
MM2 M2:DRN M2:GATE M2:SRC VSS NMOS_LVT l=0.012u w=0.03u NF=1
MM3 M3:DRN M3:GATE M3:SRC VSS NMOS_LVT l=0.012u w=0.03u NF=1
MM4 M4:DRN M4:GATE M4:SRC VSS NMOS_LVT l=0.012u w=0.03u NF=1
MM5 M5:DRN M5:GATE M5:SRC VSS NMOS_LVT l=0.012u w=0.03u NF=1
MM6 M6:DRN M6:GATE M6:SRC VSS NMOS_LVT l=0.012u w=0.03u NF=1
MM7 M7:DRN M7:GATE M7:SRC VDD PMOS_LVT l=0.012u w=0.03u NF=1
MM8 M8:DRN M8:GATE M8:SRC VDD PMOS_LVT l=0.012u w=0.03u NF=1
MM9 M9:DRN M9:GATE M9:SRC VDD PMOS_LVT l=0.012u w=0.03u NF=1

.ENDS
