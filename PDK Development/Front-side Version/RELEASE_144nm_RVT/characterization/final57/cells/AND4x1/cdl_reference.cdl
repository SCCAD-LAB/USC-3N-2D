* CANDIDATE independent circuit from preserved2024 prior-layout DSPF.
* All resistive segments collapsed to ideal wires; capacitors omitted for LVS topology.
* Not extracted from the new144nmDUT. Requires independent review before gold admission.
* Source /cedar/cedar_coe/ece-limsk/sw.jung/pdk/LIB_issue_fix/final_w17_pdk/1_fspr/10_liberate_final_fspr_rvt/NETLIST/AND4x1.spf
.SUBCKT AND4x1 A B C D VDD VSS Y
MMM9 Y MM3:DRN VSS nmos_rvt l=0.012u w=0.03u
MMM4 MM3:DRN A VDD pmos_rvt l=0.012u w=0.03u
MMM3 MM3:DRN D MM2:DRN nmos_rvt l=0.012u w=0.03u
MMM2 MM2:DRN C MM1:DRN nmos_rvt l=0.012u w=0.03u
MMM1 MM1:DRN B MM0:DRN nmos_rvt l=0.012u w=0.03u
MMM0 MM0:DRN A VSS nmos_rvt l=0.012u w=0.03u
MMM8 Y MM3:DRN VDD pmos_rvt l=0.012u w=0.03u
MMM7 MM3:DRN D VDD pmos_rvt l=0.012u w=0.03u
MMM6 MM3:DRN C VDD pmos_rvt l=0.012u w=0.03u
MMM5 MM3:DRN B VDD pmos_rvt l=0.012u w=0.03u
.ends AND4x1
