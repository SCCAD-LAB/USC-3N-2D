*
*|DSPF 1.3
*|DESIGN BUFx2
*|DATE "Tue Nov  3 20:51:53 2026"
*|VENDOR "Synopsys"
*|PROGRAM "StarRC"
*|VERSION "X-2025.06-SP1"
*|DIVIDER /
*|DELIMITER :
**FORMAT SPF
*

** COMMENTS

** OPERATING_TEMPERATURE 25
** GLOBAL_TEMPERATURE 25
**
** TCAD_GRD_FILE /cedar/cedar_coe/ece-limsk/yhuang861/GRO/.planning/experiments_migrated_20261022/usc144_github_release_20261103/sources/github_FSPR.nxtgrd
**   TCAD_TIME_STAMP Tue Mar 31 05:07:55 2026
**   TCADGRD_VERSION 89

.SUBCKT BUFx2 VSS VDD A Y

*|GROUND_NET VSS

*|NET VSS 4.26418e-05PF
*|P (VSS B 0 0.1050 0.0000)
*|I (M1:DRN M1 DRN B 0 0.1740 0.0360)
*|I (M2:SRC M2 SRC B 0 0.1200 0.0360)
*|I (M3:DRN M3 DRN B 0 0.0900 0.0360)
*|I (M4:SRC M4 SRC B 0 0.0360 0.0360)
Cg1_1 VSS:6 VSS 2.68769e-19
Cg1_2 VSS:7 VSS 2.68769e-19
Cg1_3 VSS:8 VSS 1.78742e-19
Cg1_4 VSS:11 VSS 2.50387e-18
Cg1_5 VSS:15 VSS 6.15767e-18
Cg1_6 VSS:16 VSS 5.96896e-19
Cg1_7 VSS:17 VSS 5.02728e-19
R1_1 VSS VSS:9 50.1665
R1_2 VSS VSS:10 50.1665
R1_3 VSS VSS:16 31.764
R1_4 M1:DRN VSS:14 30000.0
R1_5 M1:DRN VSS:8 30000.0
R1_6 M1:DRN VSS:24 15000.0
R1_7 M2:SRC VSS:13 30000.0
R1_8 M2:SRC VSS:7 30000.0
R1_9 M2:SRC VSS:22 15000.0
R1_10 M3:DRN VSS:13 30000.0
R1_11 M3:DRN VSS:7 30000.0
R1_12 M3:DRN VSS:22 15000.0
R1_13 M4:SRC VSS:12 30000.0
R1_14 M4:SRC VSS:6 30000.0
R1_15 M4:SRC VSS:20 15000.0
R1_16 VSS:6 VSS:20 7.8411
R1_17 VSS:6 VSS:17 12.4587
R1_18 VSS:7 VSS:22 7.84041
R1_19 VSS:7 VSS:16 12.4587
R1_20 VSS:8 VSS:24 7.8411
R1_21 VSS:8 VSS:11 12.4587
R1_22 VSS:9 VSS:15 17.9166
R1_23 VSS:9 VSS:17 31.764
R1_24 VSS:10 VSS:11 31.764
R1_25 VSS:10 VSS:26 17.9166
R1_26 VSS:11 VSS:16 100.37
R1_27 VSS:11 VSS:19 34.3372
R1_28 VSS:12 VSS:20 7.8411
R1_29 VSS:12 VSS:21 1.77981
R1_30 VSS:13 VSS:22 7.84041
R1_31 VSS:13 VSS:23 1.77981
R1_32 VSS:14 VSS:24 7.8411
R1_33 VSS:14 VSS:25 1.77981
R1_34 VSS:16 VSS:17 100.37
R1_35 VSS:17 VSS:18 34.3372

*|NET VDD 4.71104e-05PF
*|P (VDD B 0 0.1050 0.1440)
*|I (M5:DRN M5 DRN B 0 0.1740 0.1080)
*|I (M6:SRC M6 SRC B 0 0.1200 0.1080)
*|I (M7:DRN M7 DRN B 0 0.0900 0.1080)
*|I (M8:SRC M8 SRC B 0 0.0360 0.1080)
C2_1 VDD:11 VSS:11 4.19119e-19
C2_2 VDD:12 VSS:11 6.70033e-21
C2_3 VDD:14 VSS:11 2.00992e-20
C2_4 VDD:15 VSS:11 7.79004e-20
C2_5 VDD:17 VSS:11 6.39187e-20
C2_6 VDD:11 VSS:15 2.76282e-20
C2_7 VDD:15 VSS:15 5.95297e-19
C2_8 VDD:13 VSS:16 2.26115e-20
C2_9 VDD:16 VSS:16 4.49535e-19
C2_10 VDD:12 VSS:17 2.26115e-20
C2_11 VDD:17 VSS:17 4.49535e-19
Cg2_12 VDD:6 VSS 2.68918e-19
Cg2_13 VDD:7 VSS 2.68918e-19
Cg2_14 VDD:8 VSS 1.78742e-19
Cg2_15 VDD:11 VSS 1.14197e-17
Cg2_16 VDD:12 VSS 5.43919e-21
Cg2_17 VDD:15 VSS 6.12704e-18
Cg2_18 VDD:16 VSS 7.93296e-19
Cg2_19 VDD:17 VSS 8.09288e-19
R2_1 VDD VDD:9 50.1665
R2_2 VDD VDD:10 50.1665
R2_3 VDD VDD:16 31.764
R2_4 M5:DRN VDD:14 30000.0
R2_5 M5:DRN VDD:8 30000.0
R2_6 M5:DRN VDD:24 15000.0
R2_7 M6:SRC VDD:13 30000.0
R2_8 M6:SRC VDD:7 30000.0
R2_9 M6:SRC VDD:22 15000.0
R2_10 M7:DRN VDD:13 30000.0
R2_11 M7:DRN VDD:7 30000.0
R2_12 M7:DRN VDD:22 15000.0
R2_13 M8:SRC VDD:12 30000.0
R2_14 M8:SRC VDD:6 30000.0
R2_15 M8:SRC VDD:20 15000.0
R2_16 VDD:6 VDD:20 7.8411
R2_17 VDD:6 VDD:21 1.77981
R2_18 VDD:7 VDD:22 7.84041
R2_19 VDD:7 VDD:23 1.77981
R2_20 VDD:8 VDD:24 7.8411
R2_21 VDD:8 VDD:25 1.77981
R2_22 VDD:9 VDD:15 17.9166
R2_23 VDD:9 VDD:17 31.764
R2_24 VDD:10 VDD:11 31.764
R2_25 VDD:10 VDD:26 17.9166
R2_26 VDD:11 VDD:14 12.4587
R2_27 VDD:11 VDD:16 100.37
R2_28 VDD:11 VDD:19 34.3372
R2_29 VDD:12 VDD:20 7.8411
R2_30 VDD:12 VDD:17 12.4587
R2_31 VDD:13 VDD:22 7.84041
R2_32 VDD:13 VDD:16 12.4587
R2_33 VDD:14 VDD:24 7.8411
R2_34 VDD:16 VDD:17 100.37
R2_35 VDD:17 VDD:18 34.3372

*|NET A 2.71727e-05PF
*|P (A B 0 0.0210 0.0720)
*|I (M3:GATE M3 GATE I 3.6e-19 0.0840 0.0360)
*|I (M4:GATE M4 GATE I 3.6e-19 0.0420 0.0360)
*|I (M7:GATE M7 GATE I 3.6e-19 0.0840 0.1080)
*|I (M8:GATE M8 GATE I 3.6e-19 0.0420 0.1080)
C3_1 A VSS:6 2.50302e-19
C3_2 A VSS:11 9.50471e-20
C3_3 A:6 VSS:11 4.60642e-19
C3_4 A:7 VSS:11 7.89427e-21
C3_5 A:10 VSS:11 4.59524e-19
C3_6 A:11 VSS:11 7.89427e-21
C3_7 A:18 VSS:11 2.22114e-20
C3_8 A VSS:12 4.88628e-20
C3_9 A VSS:15 1.40904e-18
C3_10 A:6 VSS:15 2.2911e-20
C3_11 A:10 VSS:15 2.5889e-20
C3_12 A:18 VSS:15 5.2011e-19
C3_13 A:10 VSS:16 1.02173e-19
C3_14 A VSS:17 5.6471e-19
C3_15 A:18 VSS:17 2.32295e-19
C3_16 A:19 VDD:6 1.1494e-19
C3_17 A:9 VDD:11 1.14913e-19
C3_18 A:14 VDD:11 1.15217e-19
C3_19 A:19 VDD:12 1.20519e-19
C3_20 A:9 VDD:15 5.72243e-20
C3_21 A:14 VDD:15 5.14487e-20
C3_22 A:18 VDD:15 5.2011e-19
C3_23 A:19 VDD:15 1.41696e-18
C3_24 A:18 VDD:17 9.9272e-21
C3_25 A:19 VDD:17 4.78994e-19
Cg3_26 A VSS 1.62188e-18
Cg3_27 A:6 VSS 1.08842e-19
Cg3_28 A:8 VSS 3.4119e-19
Cg3_29 A:9 VSS 2.25021e-19
Cg3_30 A:10 VSS 2.08947e-19
Cg3_31 A:12 VSS 3.4119e-19
Cg3_32 A:14 VSS 2.27134e-19
Cg3_33 A:15 VSS 3.31311e-19
Cg3_34 A:18 VSS 8.02252e-19
Cg3_35 A:19 VSS 1.69275e-18
R3_1 A A:16 25.0832
R3_2 A A:19 29.4429
R3_3 A A:23 27.5916
R3_4 M3:GATE A:11 7.57576
R3_5 M3:GATE A:10 7.57576
R3_6 M4:GATE A:7 7.57576
R3_7 M4:GATE A:6 7.57576
R3_8 M7:GATE A:13 7.57576
R3_9 M7:GATE A:12 7.57576
R3_10 M8:GATE A:9 13.1313
R3_11 M8:GATE A:8 7.57576
R3_12 A:6 A:20 5.55556
R3_13 A:7 A:15 10.6061
R3_14 A:8 A:15 10.6061
R3_15 A:10 A:21 5.55556
R3_16 A:11 A:22 10.6061
R3_17 A:12 A:22 10.6061
R3_18 A:13 A:14 5.55556
R3_19 A:15 A:17 27.7339
R3_20 A:16 A:17 63.5281
R3_21 A:16 A:18 3.58332
R3_22 A:17 A:22 27.7339

*|NET Y 3.73542e-05PF
*|P (Y B 0 0.1890 0.0720)
*|I (M1:SRC M1 SRC B 0 0.1620 0.0360)
*|I (M2:DRN M2 DRN B 0 0.1320 0.0360)
*|I (M5:SRC M5 SRC B 0 0.1620 0.1080)
*|I (M6:DRN M6 DRN B 0 0.1320 0.1080)
C4_1 M2:DRN VSS:7 2.82443e-20
C4_2 Y:14 VSS:7 6.00618e-20
C4_3 Y:14 VSS:8 2.79721e-19
C4_4 M2:DRN VSS:11 2.09115e-20
C4_5 Y:6 VSS:11 2.32212e-18
C4_6 Y:14 VSS:11 1.00703e-18
C4_7 Y:15 VSS:11 1.33351e-19
C4_8 Y:6 VSS:14 3.27859e-20
C4_9 Y:8 VSS:14 3.18486e-20
C4_10 Y:14 VSS:14 6.37557e-20
C4_11 Y:6 VSS:15 1.69702e-19
C4_12 Y:14 VSS:15 4.18596e-18
C4_13 Y:15 VSS:15 3.14265e-20
C4_14 M2:DRN VSS:16 1.31015e-19
C4_15 Y:14 VSS:16 6.69757e-20
C4_16 M6:DRN VDD:7 2.82443e-20
C4_17 Y:15 VDD:7 5.97423e-20
C4_18 Y:14 VDD:8 1.645e-19
C4_19 Y:15 VDD:8 1.16221e-19
C4_20 Y:7 VDD:11 1.19561e-18
C4_21 Y:14 VDD:11 2.07469e-19
C4_22 Y:15 VDD:11 3.22449e-19
C4_23 Y:7 VDD:14 4.41973e-20
C4_24 Y:9 VDD:14 3.18808e-20
C4_25 Y:14 VDD:14 2.28626e-20
C4_26 Y:15 VDD:14 4.10334e-20
C4_27 Y:7 VDD:15 2.82874e-19
C4_28 Y:14 VDD:15 1.12165e-19
C4_29 Y:15 VDD:15 4.12757e-18
C4_30 M6:DRN VDD:16 3.81728e-20
C4_31 Y:15 VDD:16 6.48621e-20
Cg4_32 Y:6 VSS 3.53121e-19
Cg4_33 Y:7 VSS 2.97398e-19
Cg4_34 Y:8 VSS 2.20595e-19
Cg4_35 Y:9 VSS 2.20434e-19
Cg4_36 Y:14 VSS 3.44986e-18
Cg4_37 Y:15 VSS 1.21699e-18
R4_1 Y Y:15 25.8596
R4_2 Y Y:14 25.7999
R4_3 M1:SRC Y:8 30000.0
R4_4 M1:SRC Y:16 20270.3
R4_5 M1:SRC Y:6 57692.3
R4_6 M1:SRC Y:11 30000.0
R4_7 M2:DRN Y:8 30000.0
R4_8 M2:DRN Y:16 20270.3
R4_9 M2:DRN Y:6 57692.3
R4_10 M2:DRN Y:11 30000.0
R4_11 M5:SRC Y:7 30000.0
R4_12 M5:SRC Y:17 20089.3
R4_13 M5:SRC Y:9 59210.5
R4_14 M5:SRC Y:13 30000.0
R4_15 M6:DRN Y:7 30000.0
R4_16 M6:DRN Y:17 20089.3
R4_17 M6:DRN Y:9 59210.5
R4_18 M6:DRN Y:13 30000.0
R4_19 Y:6 Y:11 5.51634
R4_20 Y:7 Y:13 14.1199
R4_21 Y:7 Y:17 8.62446
R4_22 Y:8 Y:11 14.0605
R4_23 Y:8 Y:16 49500.0
R4_24 Y:9 Y:13 5.45702
R4_25 Y:10 Y:11 63.5281
R4_26 Y:10 Y:18 3.58332
R4_27 Y:10 Y:14 25.0832
R4_28 Y:11 Y:16 3.7634
R4_29 Y:12 Y:13 63.5281
R4_30 Y:12 Y:19 3.58332
R4_31 Y:12 Y:15 25.0832
R4_32 Y:13 Y:17 21900.0

*|NET 5 6.03557e-05PF
*|I (M1:GATE M1 GATE I 3.6e-19 0.1680 0.0360)
*|I (M2:GATE M2 GATE I 3.6e-19 0.1260 0.0360)
*|I (M3:SRC M3 SRC B 0 0.0780 0.0360)
*|I (M4:DRN M4 DRN B 0 0.0480 0.0360)
*|I (M5:GATE M5 GATE I 3.6e-19 0.1680 0.1080)
*|I (M6:GATE M6 GATE I 3.6e-19 0.1260 0.1080)
*|I (M7:SRC M7 SRC B 0 0.0780 0.1080)
*|I (M8:DRN M8 DRN B 0 0.0480 0.1080)
C6_1 M4:DRN VSS:6 2.82443e-20
C6_2 5:30 VSS:6 6.00618e-20
C6_3 5:10 VSS:7 1.2432e-18
C6_4 5:30 VSS:7 1.0873e-19
C6_5 5:32 VSS:7 1.63475e-19
C6_6 M4:DRN VSS:11 2.09115e-20
C6_7 5:9 VSS:11 4.61316e-19
C6_8 5:10 VSS:11 7.89427e-21
C6_9 5:14 VSS:11 4.68614e-19
C6_10 5:15 VSS:11 7.89427e-21
C6_11 5:19 VSS:11 2.32212e-18
C6_12 5:30 VSS:11 2.12386e-19
C6_13 5:33 VSS:11 2.22114e-20
C6_14 5:19 VSS:13 3.37061e-20
C6_15 5:22 VSS:13 3.18486e-20
C6_16 5:30 VSS:13 5.24451e-20
C6_17 5:32 VSS:13 2.27223e-20
C6_18 5:9 VSS:15 3.76747e-20
C6_19 5:14 VSS:15 5.88006e-20
C6_20 5:19 VSS:15 1.80348e-19
C6_21 5:30 VSS:15 4.14608e-18
C6_22 5:31 VSS:15 3.06687e-20
C6_23 5:32 VSS:15 7.65066e-20
C6_24 5:33 VSS:15 4.91225e-19
C6_25 5:10 VSS:16 6.90814e-19
C6_26 5:11 VSS:16 1.84692e-19
C6_27 5:14 VSS:16 1.95626e-20
C6_28 5:30 VSS:16 3.51605e-19
C6_29 5:32 VSS:16 3.73265e-19
C6_30 5:33 VSS:16 2.32295e-19
C6_31 M4:DRN VSS:17 2.13821e-20
C6_32 5:30 VSS:17 6.48621e-20
C6_33 M8:DRN VDD:6 2.82443e-20
C6_34 5:31 VDD:6 5.97423e-20
C6_35 5:12 VDD:7 1.24322e-18
C6_36 5:31 VDD:7 1.08723e-19
C6_37 5:32 VDD:7 1.64545e-19
C6_38 5:13 VDD:11 1.16922e-19
C6_39 5:18 VDD:11 1.24307e-19
C6_40 5:20 VDD:11 1.19561e-18
C6_41 5:20 VDD:13 2.80634e-20
C6_42 5:23 VDD:13 3.18808e-20
C6_43 5:31 VDD:13 5.24451e-20
C6_44 5:32 VDD:13 2.28626e-20
C6_45 5:13 VDD:15 1.12185e-19
C6_46 5:18 VDD:15 1.00465e-19
C6_47 5:20 VDD:15 2.93532e-19
C6_48 5:30 VDD:15 2.64457e-20
C6_49 5:31 VDD:15 4.14655e-18
C6_50 5:32 VDD:15 7.66479e-20
C6_51 5:33 VDD:15 4.91225e-19
C6_52 5:11 VDD:16 1.84692e-19
C6_53 5:12 VDD:16 6.90823e-19
C6_54 5:13 VDD:16 2.56403e-19
C6_55 5:18 VDD:16 3.93596e-22
C6_56 5:31 VDD:16 3.51068e-19
C6_57 5:32 VDD:16 2.03105e-19
C6_58 5:33 VDD:16 9.9272e-21
C6_59 M8:DRN VDD:17 2.13821e-20
C6_60 5:31 VDD:17 6.48621e-20
C6_61 5:30 A 9.02737e-19
C6_62 5:32 A 5.32676e-19
C6_63 5:33 A 6.07487e-21
C6_64 5:9 A:10 3.12363e-20
C6_65 5:30 A:10 9.96357e-21
C6_66 5:19 A:11 6.85177e-19
C6_67 5:22 A:11 1.23001e-18
C6_68 5:30 A:11 6.90934e-20
C6_69 5:32 A:11 9.68543e-20
C6_70 5:19 A:12 1.83539e-19
C6_71 5:20 A:12 1.83539e-19
C6_72 5:30 A:12 1.1048e-19
C6_73 5:31 A:12 4.98609e-20
C6_74 5:32 A:12 1.50833e-19
C6_75 5:31 A:13 5.05415e-20
C6_76 5:31 A:14 1.9335e-20
C6_77 M8:DRN A:15 2.0928e-20
C6_78 5:19 A:15 1.17406e-18
C6_79 5:20 A:15 2.34305e-18
C6_80 5:31 A:15 8.33949e-20
C6_81 5:33 A:15 1.86367e-19
C6_82 5:19 A:18 3.69061e-19
C6_83 5:20 A:18 2.06726e-19
C6_84 5:30 A:18 7.77083e-19
C6_85 5:31 A:18 7.74795e-19
C6_86 5:32 A:18 2.09368e-19
C6_87 5:33 A:18 4.73712e-19
C6_88 5:31 A:19 9.31521e-19
C6_89 5:32 A:19 5.54189e-19
C6_90 5:33 A:19 6.07487e-21
C6_91 5:21 M6:DRN 2.0928e-20
C6_92 5:14 Y:6 1.82222e-19
C6_93 5:15 Y:6 6.89749e-19
C6_94 5:16 Y:6 1.86805e-19
C6_95 5:21 Y:6 1.17406e-18
C6_96 5:33 Y:6 3.54276e-19
C6_97 5:16 Y:7 1.83539e-19
C6_98 5:17 Y:7 6.85193e-19
C6_99 5:18 Y:7 1.82222e-19
C6_100 5:21 Y:7 2.34305e-18
C6_101 5:33 Y:7 1.9194e-19
C6_102 5:15 Y:8 1.23001e-18
C6_103 5:17 Y:9 1.23015e-18
C6_104 5:10 Y:14 4.698e-20
C6_105 5:11 Y:14 4.36768e-20
C6_106 5:15 Y:14 1.38958e-19
C6_107 5:16 Y:14 2.25144e-19
C6_108 5:17 Y:14 9.74522e-20
C6_109 5:21 Y:14 2.14361e-19
C6_110 5:30 Y:14 9.00926e-19
C6_111 5:31 Y:14 1.09774e-20
C6_112 5:32 Y:14 1.14425e-18
C6_113 5:33 Y:14 1.55608e-18
C6_114 5:12 Y:15 4.698e-20
C6_115 5:17 Y:15 4.2117e-20
C6_116 5:21 Y:15 8.33949e-20
C6_117 5:31 Y:15 8.89949e-19
C6_118 5:32 Y:15 1.00409e-19
C6_119 5:33 Y:15 7.74795e-19
Cg6_120 5:9 VSS 1.00471e-19
Cg6_121 5:11 VSS 5.60298e-19
Cg6_122 5:13 VSS 1.68135e-19
Cg6_123 5:14 VSS 9.99012e-20
Cg6_124 5:16 VSS 9.8281e-19
Cg6_125 5:18 VSS 2.37676e-19
Cg6_126 5:19 VSS 2.98862e-19
Cg6_127 5:20 VSS 2.97398e-19
Cg6_128 5:21 VSS 6.33628e-19
Cg6_129 5:22 VSS 2.20595e-19
Cg6_130 5:23 VSS 2.20434e-19
Cg6_131 5:30 VSS 9.40416e-19
Cg6_132 5:31 VSS 9.40346e-19
Cg6_133 5:32 VSS 9.03394e-19
Cg6_134 5:33 VSS 5.99375e-19
R6_1 M1:GATE 5:15 7.57576
R6_2 M1:GATE 5:14 7.57576
R6_3 M2:GATE 5:10 7.57576
R6_4 M2:GATE 5:9 7.57576
R6_5 M3:SRC 5:22 30000.0
R6_6 M3:SRC 5:37 20270.3
R6_7 M3:SRC 5:19 57692.3
R6_8 M3:SRC 5:27 30000.0
R6_9 M4:DRN 5:22 30000.0
R6_10 M4:DRN 5:37 20270.3
R6_11 M4:DRN 5:19 57692.3
R6_12 M4:DRN 5:27 30000.0
R6_13 M5:GATE 5:17 7.57576
R6_14 M5:GATE 5:16 7.57576
R6_15 M6:GATE 5:12 7.57576
R6_16 M6:GATE 5:11 7.57576
R6_17 M7:SRC 5:20 30000.0
R6_18 M7:SRC 5:38 20089.3
R6_19 M7:SRC 5:23 59210.5
R6_20 M7:SRC 5:29 30000.0
R6_21 M8:DRN 5:20 30000.0
R6_22 M8:DRN 5:38 20089.3
R6_23 M8:DRN 5:23 59210.5
R6_24 M8:DRN 5:29 30000.0
R6_25 5:9 5:34 5.55556
R6_26 5:10 5:21 10.6061
R6_27 5:11 5:21 10.6061
R6_28 5:12 5:13 5.55556
R6_29 5:14 5:35 5.55556
R6_30 5:15 5:36 10.6061
R6_31 5:16 5:36 10.6061
R6_32 5:17 5:18 5.55556
R6_33 5:19 5:27 5.51634
R6_34 5:20 5:29 14.1199
R6_35 5:20 5:38 8.62446
R6_36 5:21 5:25 27.7339
R6_37 5:22 5:27 14.0605
R6_38 5:22 5:37 49500.0
R6_39 5:23 5:29 5.45702
R6_40 5:24 5:25 63.5281
R6_41 5:24 5:32 25.0832
R6_42 5:24 5:33 3.58332
R6_43 5:25 5:36 27.7339
R6_44 5:26 5:27 63.5281
R6_45 5:26 5:39 3.58332
R6_46 5:26 5:30 25.0832
R6_47 5:27 5:37 3.7634
R6_48 5:28 5:29 63.5281
R6_49 5:28 5:40 3.58332
R6_50 5:28 5:31 25.0832
R6_51 5:29 5:38 21900.0
R6_52 5:30 5:32 25.7999
R6_53 5:31 5:32 25.8596

*|NET 7 4.56161e-05PF
C7_1 7:1 VSS:6 8.03132e-19
C7_2 7:1 VSS:11 3.93101e-20
C7_3 7:3 VSS:11 1.35956e-19
C7_4 7:1 VSS:15 4.22285e-19
C7_5 7:2 VSS:15 5.20881e-19
C7_6 7:3 VSS:15 3.20198e-20
C7_7 7:1 VSS:17 1.50135e-18
C7_8 7:1 VDD:6 8.03136e-19
C7_9 7:1 VDD:15 1.05245e-18
C7_10 7:1 VDD:16 3.47913e-19
C7_11 7:1 VDD:17 1.50126e-18
C7_12 7:1 A 4.45737e-19
C7_13 7:1 A:18 1.75524e-19
C7_14 7:1 A:19 3.76819e-19
C7_15 7:1 Y:14 6.00275e-19
C7_16 7:2 Y:14 9.51119e-20
C7_17 7:3 Y:14 1.55906e-19
C7_18 7:1 Y:15 3.49173e-19
C7_19 7:1 5:19 1.0432e-20
C7_20 7:2 5:19 1.80413e-19
C7_21 7:1 5:20 8.8355e-19
C7_22 7:1 5:21 5.41347e-21
C7_23 7:1 5:23 7.99905e-19
C7_24 7:1 5:30 1.74548e-19
C7_25 7:2 5:30 5.29387e-20
C7_26 7:1 5:31 2.46902e-19
C7_27 7:1 5:32 2.49804e-19
C7_28 7:1 5:33 2.22661e-19
Cg7_29 7:1 VSS 2.82374e-17
Cg7_30 7:2 VSS 3.96707e-18
R7_1 7:1 7:2 10289.6
R7_2 7:2 7:3 1326.22

*|NET 8 0PF
R8_1 8:1 8:2 39455.2

*|NET _generated_10 3.08088e-06PF
C9_1 _generated_10:1 VSS:11 1.47021e-19
C9_2 _generated_10:1 VDD:11 1.18927e-19
C9_3 _generated_10:1 VDD:15 4.89892e-20
C9_4 _generated_10:1 VDD:17 3.74453e-19
C9_5 _generated_10:1 A:19 3.15962e-19
C9_6 _generated_10:1 7:1 5.65589e-19
Cg9_7 _generated_10:1 VSS 9.3089e-19
R9_1 _generated_10:1 _generated_10:2 28.2828

*|NET _generated_11 5.37479e-06PF
C10_1 _generated_11:1 VSS:11 9.21148e-19
C10_2 _generated_11:1 VSS:15 9.68154e-20
C10_3 _generated_11:1 5:11 7.90108e-21
C10_4 _generated_11:1 5:14 1.58022e-21
C10_5 _generated_11:1 5:16 2.39886e-19
Cg10_6 _generated_11:1 VSS 3.50331e-18
R10_1 _generated_11:1 _generated_11:2 28.2828

*|NET _generated_12 5.0073e-06PF
C11_1 _generated_12:1 VDD:11 5.78695e-19
C11_2 _generated_12:1 VDD:15 1.91825e-19
C11_3 _generated_12:1 5:11 7.90108e-21
C11_4 _generated_12:1 5:16 2.39886e-19
C11_5 _generated_12:1 5:18 1.58022e-21
C11_6 _generated_12:1 _generated_11:1 6.0415e-19
Cg11_7 _generated_12:1 VSS 3.38326e-18
R11_1 _generated_12:1 _generated_12:2 28.2828

*|NET _generated_9 2.86348e-06PF
C12_1 _generated_9:1 VSS:15 2.25577e-20
C12_2 _generated_9:1 VSS:17 3.44976e-19
C12_3 _generated_9:1 A 3.06042e-19
C12_4 _generated_9:1 7:1 6.61239e-19
C12_5 _generated_9:1 _generated_10:1 5.79044e-19
Cg12_6 _generated_9:1 VSS 9.49624e-19
R12_1 _generated_9:1 _generated_9:2 28.2828

*
* Instance Section
*
MM1 M1:DRN M1:GATE M1:SRC VSS NMOS_LVT l=0.012u w=0.03u NF=1
MM2 M2:DRN M2:GATE M2:SRC VSS NMOS_LVT l=0.012u w=0.03u NF=1
MM3 M3:DRN M3:GATE M3:SRC VSS NMOS_LVT l=0.012u w=0.03u NF=1
MM4 M4:DRN M4:GATE M4:SRC VSS NMOS_LVT l=0.012u w=0.03u NF=1
MM5 M5:DRN M5:GATE M5:SRC VDD PMOS_LVT l=0.012u w=0.03u NF=1
MM6 M6:DRN M6:GATE M6:SRC VDD PMOS_LVT l=0.012u w=0.03u NF=1
MM7 M7:DRN M7:GATE M7:SRC VDD PMOS_LVT l=0.012u w=0.03u NF=1
MM8 M8:DRN M8:GATE M8:SRC VDD PMOS_LVT l=0.012u w=0.03u NF=1

.ENDS
