*
*|DSPF 1.3
*|DESIGN NAND3x1
*|DATE "Tue Nov  3 20:52:54 2026"
*|VENDOR "Synopsys"
*|PROGRAM "StarRC"
*|VERSION "X-2025.06-SP1"
*|DIVIDER /
*|DELIMITER :
**FORMAT SPF
*

** COMMENTS

** OPERATING_TEMPERATURE 25
** GLOBAL_TEMPERATURE 25
**
** TCAD_GRD_FILE /cedar/cedar_coe/ece-limsk/yhuang861/GRO/.planning/experiments_migrated_20261022/usc144_github_release_20261103/sources/github_FSPR.nxtgrd
**   TCAD_TIME_STAMP Tue Mar 31 05:07:55 2026
**   TCADGRD_VERSION 89

.SUBCKT NAND3x1 VSS VDD Y A B C

*|GROUND_NET VSS

*|NET VSS 6.46985e-05PF
*|P (VSS B 0 0.0840 0.0000)
*|I (M3:SRC M3 SRC B 0 0.0360 0.0360)
Cg1_1 VSS:3 VSS 2.52098e-19
Cg1_2 VSS:5 VSS 2.12155e-18
Cg1_3 VSS:12 VSS 2.45738e-17
Cg1_4 VSS:14 VSS 4.37685e-18
Cg1_5 VSS:16 VSS 5.69662e-18
R1_1 VSS VSS:8 12.5416
R1_2 VSS VSS:6 12.5416
R1_3 M3:SRC VSS:13 30000.0
R1_4 M3:SRC VSS:3 30000.0
R1_5 M3:SRC VSS:19 15000.0
R1_6 VSS:3 VSS:19 7.8411
R1_7 VSS:3 VSS:5 12.4587
R1_8 VSS:4 VSS:5 31.764
R1_9 VSS:4 VSS:16 17.9166
R1_10 VSS:4 VSS:6 25.0832
R1_11 VSS:5 VSS:7 50.1851
R1_12 VSS:5 VSS:17 34.3372
R1_13 VSS:6 VSS:7 63.5281
R1_14 VSS:7 VSS:9 55.4677
R1_15 VSS:8 VSS:9 63.5281
R1_16 VSS:8 VSS:10 25.0832
R1_17 VSS:9 VSS:11 55.4677
R1_18 VSS:10 VSS:11 63.5281
R1_19 VSS:10 VSS:21 17.9166
R1_20 VSS:11 VSS:18 39.6198
R1_21 VSS:12 VSS:14 7112.68
R1_22 VSS:13 VSS:19 7.8411
R1_23 VSS:13 VSS:20 1.77981
R1_24 VSS:14 VSS:15 2057.93
R1_25 VSS:5 VSS:12 0.01

*|NET VDD 4.20976e-05PF
*|P (VDD B 0 0.0840 0.1440)
*|I (M4:SRC M4 SRC B 0 0.1200 0.1080)
*|I (M5:DRN M5 DRN B 0 0.0900 0.1080)
*|I (M6:SRC M6 SRC B 0 0.0360 0.1080)
C2_1 VDD VSS:5 7.87793e-20
C2_2 VDD:11 VSS:5 3.83957e-20
C2_3 VDD:14 VSS:5 1.05716e-20
C2_4 VDD:17 VSS:5 1.84332e-19
C2_5 VDD VSS:12 1.12054e-18
C2_6 VDD:5 VSS:12 8.02899e-19
C2_7 VDD:11 VSS:12 3.57217e-19
C2_8 VDD:17 VSS:12 1.31603e-18
C2_9 VDD VSS:16 8.93416e-19
C2_10 VDD:11 VSS:16 2.76282e-20
Cg2_11 VDD VSS 5.98424e-18
Cg2_12 VDD:5 VSS 2.76091e-19
Cg2_13 VDD:6 VSS 2.41358e-19
Cg2_14 VDD:11 VSS 9.47543e-18
Cg2_15 VDD:14 VSS 5.43919e-21
Cg2_16 VDD:17 VSS 8.29438e-19
R2_1 VDD VDD:8 12.5416
R2_2 VDD VDD:10 12.5416
R2_3 VDD VDD:15 0.1
R2_4 M4:SRC VDD:16 30000.0
R2_5 M4:SRC VDD:6 30000.0
R2_6 M4:SRC VDD:22 15000.0
R2_7 M5:DRN VDD:16 30000.0
R2_8 M5:DRN VDD:6 30000.0
R2_9 M5:DRN VDD:22 15000.0
R2_10 M6:SRC VDD:14 30000.0
R2_11 M6:SRC VDD:5 30000.0
R2_12 M6:SRC VDD:20 15000.0
R2_13 VDD:5 VDD:20 7.8411
R2_14 VDD:5 VDD:21 1.77981
R2_15 VDD:6 VDD:22 7.84041
R2_16 VDD:6 VDD:23 1.77981
R2_17 VDD:7 VDD:24 17.9166
R2_18 VDD:7 VDD:8 25.0832
R2_19 VDD:7 VDD:17 31.764
R2_20 VDD:8 VDD:9 63.5281
R2_21 VDD:9 VDD:17 50.1851
R2_22 VDD:9 VDD:11 50.1851
R2_23 VDD:10 VDD:11 31.764
R2_24 VDD:10 VDD:12 25.0832
R2_25 VDD:11 VDD:13 50.1851
R2_26 VDD:11 VDD:16 12.4587
R2_27 VDD:12 VDD:13 63.5281
R2_28 VDD:12 VDD:25 17.9166
R2_29 VDD:13 VDD:19 39.6198
R2_30 VDD:14 VDD:20 7.8411
R2_31 VDD:14 VDD:17 12.4587
R2_32 VDD:16 VDD:22 7.84041
R2_33 VDD:17 VDD:18 34.3372

*|NET Y 3.63105e-05PF
*|P (Y B 0 0.1470 0.0720)
*|I (M1:DRN M1 DRN B 0 0.1320 0.0360)
*|I (M4:DRN M4 DRN B 0 0.1320 0.1080)
*|I (M5:SRC M5 SRC B 0 0.0780 0.1080)
*|I (M6:DRN M6 DRN B 0 0.0480 0.1080)
C3_1 M1:DRN VSS:5 1.73118e-20
C3_2 Y:7 VSS:5 2.32339e-18
C3_3 Y:19 VSS:5 7.56612e-20
C3_4 Y:6 VSS:12 8.82123e-19
C3_5 Y:9 VSS:12 8.02037e-19
C3_6 Y:18 VSS:12 4.74704e-19
C3_7 Y:19 VSS:12 4.05276e-19
C3_8 Y:19 VSS:14 7.77805e-20
C3_9 Y:19 VSS:15 1.90149e-19
C3_10 Y:7 VSS:16 8.93172e-20
C3_11 Y:18 VSS:16 5.78669e-19
C3_12 Y:19 VSS:16 1.54886e-18
C3_13 Y:6 VDD 1.85189e-19
C3_14 Y:8 VDD 2.56632e-19
C3_15 Y:18 VDD 6.96809e-18
C3_16 Y:19 VDD 5.09215e-20
C3_17 M6:DRN VDD:5 2.82443e-20
C3_18 Y:18 VDD:5 6.02467e-20
C3_19 M4:DRN VDD:6 3.01108e-20
C3_20 Y:18 VDD:6 1.5225e-19
C3_21 Y:19 VDD:6 4.96057e-20
C3_22 M4:DRN VDD:11 4.16022e-20
C3_23 Y:6 VDD:11 1.19561e-18
C3_24 Y:8 VDD:11 1.06277e-18
C3_25 Y:18 VDD:11 6.28971e-19
C3_26 Y:19 VDD:11 7.82117e-20
C3_27 Y:6 VDD:16 2.48114e-20
C3_28 Y:9 VDD:16 3.01108e-20
C3_29 Y:18 VDD:16 5.44158e-20
C3_30 M6:DRN VDD:17 2.13821e-20
C3_31 Y:18 VDD:17 6.53731e-20
Cg3_32 Y:6 VSS 3.35981e-19
Cg3_33 Y:7 VSS 3.15906e-19
Cg3_34 Y:8 VSS 2.8933e-19
Cg3_35 Y:9 VSS 2.55987e-19
Cg3_36 Y:10 VSS 1.78742e-19
Cg3_37 Y:11 VSS 1.78742e-19
Cg3_38 Y:18 VSS 1.57464e-18
Cg3_39 Y:19 VSS 2.63844e-18
R3_1 Y Y:16 21.4999
R3_2 Y Y:14 21.4999
R3_3 M1:DRN Y:10 30000.0
R3_4 M1:DRN Y:7 30000.0
R3_5 M1:DRN Y:15 15000.0
R3_6 M4:DRN Y:11 30000.0
R3_7 M4:DRN Y:8 30000.0
R3_8 M4:DRN Y:17 15000.0
R3_9 M5:SRC Y:6 30000.0
R3_10 M5:SRC Y:20 20089.3
R3_11 M5:SRC Y:9 59210.5
R3_12 M5:SRC Y:13 30000.0
R3_13 M6:DRN Y:6 30000.0
R3_14 M6:DRN Y:20 20089.3
R3_15 M6:DRN Y:9 59210.5
R3_16 M6:DRN Y:13 30000.0
R3_17 Y:6 Y:13 14.1199
R3_18 Y:6 Y:20 8.62446
R3_19 Y:7 Y:15 9.78801
R3_20 Y:8 Y:17 9.78801
R3_21 Y:9 Y:13 5.45702
R3_22 Y:10 Y:15 9.78801
R3_23 Y:11 Y:17 9.78801
R3_24 Y:12 Y:13 63.5281
R3_25 Y:12 Y:21 3.58332
R3_26 Y:12 Y:18 50.1665
R3_27 Y:13 Y:20 21900.0
R3_28 Y:14 Y:15 63.5281
R3_29 Y:14 Y:19 7.8833
R3_30 Y:16 Y:17 63.5281
R3_31 Y:16 Y:18 4.35971

*|NET A 2.16119e-05PF
*|P (A B 0 0.0210 0.0720)
*|I (M3:GATE M3 GATE I 3.6e-19 0.0420 0.0360)
*|I (M6:GATE M6 GATE I 3.6e-19 0.0420 0.1080)
C4_1 A:5 VSS:3 1.24456e-18
C4_2 A:10 VSS:3 2.33814e-19
C4_3 A:4 VSS:5 4.61602e-19
C4_4 A:5 VSS:5 6.97587e-19
C4_5 A:6 VSS:5 1.83918e-19
C4_6 A:8 VSS:5 9.16124e-19
C4_7 A:10 VSS:5 7.11945e-19
C4_8 A:10 VSS:12 8.11965e-19
C4_9 A:10 VSS:13 5.97872e-20
C4_10 A:4 VSS:16 3.27526e-20
C4_11 A:10 VSS:16 1.4713e-18
C4_12 A:7 VDD 9.31431e-20
C4_13 A:8 VDD 2.83023e-20
C4_14 A:10 VDD 1.47915e-18
C4_15 A:10 VDD:5 1.1494e-19
C4_16 A:7 VDD:11 1.16249e-19
C4_17 A:8 VDD:14 1.48933e-20
C4_18 A:10 VDD:14 1.22918e-19
C4_19 A:6 VDD:17 1.83918e-19
C4_20 A:8 VDD:17 1.58128e-18
C4_21 A:10 VDD:17 4.73109e-19
C4_22 A:10 Y:18 9.76393e-19
C4_23 A:10 Y:19 1.22614e-19
Cg4_24 A:4 VSS 2.38318e-19
Cg4_25 A:6 VSS 3.4119e-19
Cg4_26 A:7 VSS 1.57023e-19
Cg4_27 A:8 VSS 1.99342e-19
Cg4_28 A:10 VSS 3.5869e-18
R4_1 A A:10 29.3832
R4_2 A A:13 29.4429
R4_3 A A:9 63.5281
R4_4 M3:GATE A:5 7.57576
R4_5 M3:GATE A:4 7.57576
R4_6 M6:GATE A:7 13.1313
R4_7 M6:GATE A:6 7.57576
R4_8 A:4 A:11 5.55556
R4_9 A:5 A:8 10.6061
R4_10 A:6 A:8 10.6061
R4_11 A:8 A:9 27.7339
R4_12 A:9 A:12 7.92396

*|NET B 1.69845e-05PF
*|P (B B 0 0.0630 0.0720)
*|I (M2:GATE M2 GATE I 3.6e-19 0.0840 0.0360)
*|I (M5:GATE M5 GATE I 3.6e-19 0.0840 0.1080)
C5_1 B:11 VSS:3 8.37832e-20
C5_2 B:4 VSS:5 4.61996e-19
C5_3 B:5 VSS:5 7.89427e-21
C5_4 B:11 VSS:5 1.93815e-19
C5_5 B:11 VSS:12 2.226e-19
C5_6 B:11 VSS:14 2.65282e-20
C5_7 B:4 VSS:16 9.76367e-20
C5_8 B:11 VSS:16 1.57773e-18
C5_9 B:9 M6:DRN 1.65859e-20
C5_10 B:6 Y:6 1.83918e-19
C5_11 B:9 Y:6 1.6205e-18
C5_12 B:11 Y:6 1.03961e-19
C5_13 B:6 Y:18 5.62864e-20
C5_14 B:7 Y:18 5.16341e-20
C5_15 B:8 Y:18 1.9335e-20
C5_16 B:9 Y:18 1.24808e-19
C5_17 B:11 Y:18 1.68759e-18
C5_18 B:11 Y:19 3.16874e-19
C5_19 B:4 A:4 5.06565e-19
C5_20 B:11 A:4 1.49976e-20
C5_21 B:11 A:5 1.16886e-19
C5_22 B:11 A:6 1.7832e-19
C5_23 B:11 A:10 3.15264e-18
Cg5_24 B:4 VSS 1.02052e-19
Cg5_25 B:6 VSS 3.4119e-19
Cg5_26 B:8 VSS 3.938e-19
Cg5_27 B:9 VSS 1.743e-19
Cg5_28 B:11 VSS 1.51346e-18
R5_1 B B:11 29.3832
R5_2 B B:14 12.8402
R5_3 B B:10 63.5281
R5_4 M2:GATE B:5 7.57576
R5_5 M2:GATE B:4 7.57576
R5_6 M5:GATE B:7 7.57576
R5_7 M5:GATE B:6 7.57576
R5_8 B:4 B:12 5.55556
R5_9 B:5 B:9 10.6061
R5_10 B:6 B:9 10.6061
R5_11 B:7 B:8 5.55556
R5_12 B:9 B:10 27.7339
R5_13 B:10 B:13 7.92396

*|NET C 2.04915e-05PF
*|P (C B 0 0.1050 0.0720)
*|I (M1:GATE M1 GATE I 3.6e-19 0.1260 0.0360)
*|I (M4:GATE M4 GATE I 3.6e-19 0.1260 0.1080)
C6_1 C:4 VSS:5 4.61602e-19
C6_2 C:5 VSS:5 7.89427e-21
C6_3 C:11 VSS:5 8.83916e-20
C6_4 C:11 VSS:12 2.04269e-19
C6_5 C:11 VSS:14 2.65282e-20
C6_6 C:4 VSS:16 1.10019e-19
C6_7 C:11 VSS:16 1.65229e-18
C6_8 C:8 VDD 6.25764e-20
C6_9 C:11 VDD 1.36713e-19
C6_10 C:7 VDD:6 1.22504e-18
C6_11 C:6 VDD:11 1.83918e-19
C6_12 C:7 VDD:11 6.85454e-19
C6_13 C:8 VDD:11 3.70914e-19
C6_14 C:9 VDD:11 1.62973e-18
C6_15 C:11 VDD:11 1.12105e-19
C6_16 C:9 VDD:16 1.71158e-20
C6_17 C:11 Y:6 3.53609e-20
C6_18 C:11 Y:9 1.53602e-20
C6_19 C:6 Y:18 1.24019e-19
C6_20 C:7 Y:18 8.30522e-20
C6_21 C:8 Y:18 3.14075e-20
C6_22 C:9 Y:18 1.23172e-19
C6_23 C:11 Y:18 1.63508e-18
C6_24 C:5 Y:19 1.53969e-19
C6_25 C:6 Y:19 2.18239e-19
C6_26 C:7 Y:19 9.57709e-20
C6_27 C:9 Y:19 2.90465e-19
C6_28 C:11 Y:19 3.12777e-18
C6_29 C:4 B:4 4.50387e-20
C6_30 C:11 B:5 1.16886e-19
C6_31 C:11 B:6 1.7832e-19
C6_32 C:11 B:11 3.10074e-18
Cg6_33 C:4 VSS 1.02525e-19
Cg6_34 C:6 VSS 9.8281e-19
Cg6_35 C:8 VSS 2.3872e-19
Cg6_36 C:9 VSS 4.38732e-19
Cg6_37 C:11 VSS 1.60896e-18
R6_1 C C:11 29.3832
R6_2 C C:14 12.8402
R6_3 C C:10 63.5281
R6_4 M1:GATE C:5 7.57576
R6_5 M1:GATE C:4 7.57576
R6_6 M4:GATE C:7 7.57576
R6_7 M4:GATE C:6 7.57576
R6_8 C:4 C:12 5.55556
R6_9 C:5 C:9 10.6061
R6_10 C:6 C:9 10.6061
R6_11 C:7 C:8 5.55556
R6_12 C:9 C:10 27.7339
R6_13 C:10 C:13 7.92396

*|NET 10 8.41664e-07PF
*|I (M2:SRC M2 SRC B 0 0.0780 0.0360)
*|I (M3:DRN M3 DRN B 0 0.0480 0.0360)
C8_1 M3:DRN VSS:3 2.82443e-20
C8_2 M3:DRN VSS:5 4.98136e-19
C8_3 M3:DRN VSS:16 1.1947e-19
C8_4 M3:DRN B:11 1.95814e-19
R8_1 M2:SRC M3:DRN 15000.0

*|NET 11 7.56112e-07PF
*|I (M1:SRC M1 SRC B 0 0.1200 0.0360)
*|I (M2:DRN M2 DRN B 0 0.0900 0.0360)
C9_1 M2:DRN VSS:5 4.65606e-19
C9_2 M2:DRN VSS:16 7.74796e-20
C9_3 M2:DRN C:11 1.95814e-19
Cg9_4 M2:DRN VSS 1.72125e-20
R9_1 M1:SRC M2:DRN 15000.0

*|NET _generated_12 2.95652e-06PF
C10_1 _generated_12:1 VSS:5 3.44976e-19
C10_2 _generated_12:1 VSS:12 5.19939e-19
C10_3 _generated_12:1 VSS:14 2.43246e-20
C10_4 _generated_12:1 VSS:16 2.25577e-20
C10_5 _generated_12:1 A:5 1.08527e-19
C10_6 _generated_12:1 A:6 1.01484e-19
C10_7 _generated_12:1 A:10 3.06042e-19
Cg10_8 _generated_12:1 VSS 9.49624e-19
R10_1 _generated_12:1 _generated_12:2 28.2828

*|NET _generated_13 3.16877e-06PF
C11_1 _generated_13:1 VSS:5 1.47021e-19
C11_2 _generated_13:1 VSS:12 4.98032e-19
C11_3 _generated_13:1 VDD 4.89892e-20
C11_4 _generated_13:1 VDD:11 1.18927e-19
C11_5 _generated_13:1 VDD:17 3.74453e-19
C11_6 _generated_13:1 A:6 1.5545e-19
C11_7 _generated_13:1 A:10 3.15962e-19
C11_8 _generated_13:1 _generated_12:1 5.79044e-19
Cg11_9 _generated_13:1 VSS 9.3089e-19
R11_1 _generated_13:1 _generated_13:2 28.2828

*|NET _generated_14 5.3243e-06PF
C12_1 _generated_14:1 VSS:5 4.61748e-19
C12_2 _generated_14:1 VSS:12 2.98844e-20
C12_3 _generated_14:1 VSS:16 9.68154e-20
C12_4 _generated_14:1 Y:7 3.81915e-19
C12_5 _generated_14:1 Y:19 5.51814e-20
C12_6 _generated_14:1 C:4 4.75026e-20
C12_7 _generated_14:1 C:6 2.39886e-19
Cg12_8 _generated_14:1 VSS 3.40722e-18
R12_1 _generated_14:1 _generated_14:2 28.2828

*|NET _generated_15 4.95307e-06PF
C13_1 _generated_15:1 VDD 1.77679e-19
C13_2 _generated_15:1 VDD:11 1.1978e-19
C13_3 _generated_15:1 Y:8 3.81915e-19
C13_4 _generated_15:1 Y:19 5.9697e-20
C13_5 _generated_15:1 C:6 2.39886e-19
C13_6 _generated_15:1 C:8 4.75026e-20
C13_7 _generated_15:1 _generated_14:1 6.0415e-19
Cg13_8 _generated_15:1 VSS 3.32246e-18
R13_1 _generated_15:1 _generated_15:2 28.2828

*
* Instance Section
*
MM1 M1:DRN M1:GATE M1:SRC VSS NMOS_LVT l=0.012u w=0.03u NF=1
MM2 M2:DRN M2:GATE M2:SRC VSS NMOS_LVT l=0.012u w=0.03u NF=1
MM3 M3:DRN M3:GATE M3:SRC VSS NMOS_LVT l=0.012u w=0.03u NF=1
MM4 M4:DRN M4:GATE M4:SRC VDD PMOS_LVT l=0.012u w=0.03u NF=1
MM5 M5:DRN M5:GATE M5:SRC VDD PMOS_LVT l=0.012u w=0.03u NF=1
MM6 M6:DRN M6:GATE M6:SRC VDD PMOS_LVT l=0.012u w=0.03u NF=1

.ENDS
