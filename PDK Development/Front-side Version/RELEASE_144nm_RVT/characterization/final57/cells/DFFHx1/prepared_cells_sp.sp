*
*|DSPF 1.3
*|DESIGN DFFHx1
*|DATE "Wed Nov  4 06:30:36 2026"
*|VENDOR "Synopsys"
*|PROGRAM "StarRC"
*|VERSION "X-2025.06-SP1"
*|DIVIDER /
*|DELIMITER :
**FORMAT SPF
*

** COMMENTS

** OPERATING_TEMPERATURE 25
** GLOBAL_TEMPERATURE 25
**
** TCAD_GRD_FILE /cedar/cedar_coe/ece-limsk/yhuang861/GRO/.planning/experiments_migrated_20261022/usc144_github_release_20261103/sources/github_FSPR.nxtgrd
**   TCAD_TIME_STAMP Tue Mar 31 05:07:55 2026
**   TCADGRD_VERSION 89

.SUBCKT DFFHx1 CK SET RESET VSS VDD D QN

*|GROUND_NET VSS

*|NET CK 5.96178e-05PF
*|P (CK B 0 0.0490 0.0720)
*|I (M12:GATE M12 GATE I 1.8e-19 0.2520 0.0285)
*|I (M16:GATE M16 GATE I 3.6e-19 0.0420 0.0360)
*|I (M29:GATE M29 GATE I 3.6e-19 0.2520 0.1080)
*|I (M32:GATE M32 GATE I 3.6e-19 0.0420 0.1080)
Cg1_1 CK:6 VSS 1.09775e-19
Cg1_2 CK:8 VSS 3.4119e-19
Cg1_3 CK:9 VSS 2.27459e-19
Cg1_4 CK:10 VSS 1.09147e-19
Cg1_5 CK:12 VSS 4.63043e-19
Cg1_6 CK:13 VSS 2.29215e-19
Cg1_7 CK:14 VSS 1.55206e-19
Cg1_8 CK:15 VSS 2.16131e-19
Cg1_9 CK:23 VSS 1.78082e-18
Cg1_10 CK:24 VSS 1.16382e-18
Cg1_11 CK:25 VSS 3.0753e-18
R1_1 CK CK:17 26.2777
R1_2 CK CK:23 29.3832
R1_3 CK CK:20 63.5281
R1_4 M12:GATE CK:11 3.78788
R1_5 M12:GATE CK:10 3.78788
R1_6 M16:GATE CK:7 7.57576
R1_7 M16:GATE CK:6 7.57576
R1_8 M29:GATE CK:13 13.1313
R1_9 M29:GATE CK:12 7.57576
R1_10 M32:GATE CK:9 13.1313
R1_11 M32:GATE CK:8 7.57576
R1_12 CK:6 CK:26 5.55556
R1_13 CK:7 CK:14 10.6061
R1_14 CK:8 CK:14 10.6061
R1_15 CK:10 CK:27 5.55556
R1_16 CK:11 CK:15 18.1818
R1_17 CK:12 CK:15 10.6061
R1_18 CK:14 CK:20 9.24462
R1_19 CK:15 CK:22 27.7339
R1_20 CK:16 CK:17 63.5281
R1_21 CK:16 CK:25 7.45836
R1_22 CK:16 CK:18 113.118
R1_23 CK:17 CK:30 5.9722
R1_24 CK:18 CK:19 63.5281
R1_25 CK:18 CK:32 7.45836
R1_26 CK:19 CK:21 26.2777
R1_27 CK:19 CK:31 5.9722
R1_28 CK:20 CK:28 7.92396
R1_29 CK:21 CK:22 63.5281
R1_30 CK:21 CK:24 3.58332
R1_31 CK:22 CK:29 7.92396

*|NET SET 6.31803e-05PF
*|P (SET B 0 0.4620 0.0288)
*|I (M20:GATE M20 GATE I 2.4e-19 0.7560 0.1080)
*|I (M25:GATE M25 GATE I 2.4e-19 0.4620 0.1080)
*|I (M4:GATE M4 GATE I 2.4e-19 0.7560 0.0360)
*|I (M9:GATE M9 GATE I 2.4e-19 0.4620 0.0360)
Cg2_1 SET:6 VSS 5.47482e-19
Cg2_2 SET:7 VSS 2.19919e-20
Cg2_3 SET:8 VSS 4.54792e-19
Cg2_4 SET:9 VSS 4.89163e-19
Cg2_5 SET:10 VSS 2.20996e-20
Cg2_6 SET:11 VSS 4.34332e-19
Cg2_7 SET:16 VSS 2.06731e-19
Cg2_8 SET:18 VSS 2.06731e-19
Cg2_9 SET:19 VSS 1.65582e-18
Cg2_10 SET:20 VSS 1.82679e-18
Cg2_11 SET:21 VSS 2.52781e-18
R2_1 SET SET:13 26.5763
R2_2 SET SET:16 63.5281
R2_3 M20:GATE SET:10 5.05051
R2_4 M20:GATE SET:9 5.05051
R2_5 M25:GATE SET:7 5.05051
R2_6 M25:GATE SET:6 5.05051
R2_7 M4:GATE SET:9 31.3131
R2_8 M4:GATE SET:18 3.63636
R2_9 M9:GATE SET:6 31.3131
R2_10 M9:GATE SET:16 3.63636
R2_11 SET:7 SET:8 8.08081
R2_12 SET:10 SET:11 8.08081
R2_13 SET:12 SET:13 63.5281
R2_14 SET:12 SET:21 3.72918
R2_15 SET:12 SET:14 78.3128
R2_16 SET:13 SET:19 3.58332
R2_17 SET:14 SET:15 63.5281
R2_18 SET:14 SET:25 3.72918
R2_19 SET:15 SET:20 3.58332
R2_20 SET:15 SET:17 75.2497
R2_21 SET:16 SET:22 7.9798
R2_22 SET:17 SET:18 63.5281
R2_23 SET:17 SET:24 3.58332
R2_24 SET:18 SET:23 7.9798

*|NET RESET 6.00506e-05PF
*|P (RESET B 0 0.4200 0.1153)
*|I (M10:GATE M10 GATE I 2.4e-19 0.4200 0.0360)
*|I (M21:GATE M21 GATE I 2.4e-19 0.7140 0.1080)
*|I (M26:GATE M26 GATE I 2.4e-19 0.4200 0.1080)
*|I (M5:GATE M5 GATE I 2.4e-19 0.7140 0.0360)
Cg3_1 RESET:6 VSS 6.19266e-19
Cg3_2 RESET:7 VSS 3.70134e-20
Cg3_3 RESET:8 VSS 4.80907e-19
Cg3_4 RESET:9 VSS 2.67751e-19
Cg3_5 RESET:10 VSS 6.47809e-19
Cg3_6 RESET:11 VSS 3.01389e-20
Cg3_7 RESET:12 VSS 5.3215e-19
Cg3_8 RESET:13 VSS 2.67751e-19
Cg3_9 RESET:18 VSS 9.07786e-20
Cg3_10 RESET:20 VSS 9.07786e-20
Cg3_11 RESET:21 VSS 2.21513e-18
Cg3_12 RESET:22 VSS 2.3906e-18
Cg3_13 RESET:23 VSS 2.44447e-18
R3_1 RESET RESET:15 51.6595
R3_2 RESET RESET:18 63.5281
R3_3 M10:GATE RESET:7 5.05051
R3_4 M10:GATE RESET:6 5.05051
R3_5 M21:GATE RESET:20 3.66162
R3_6 M21:GATE RESET:12 5.05051
R3_7 M26:GATE RESET:18 3.66162
R3_8 M26:GATE RESET:8 5.05051
R3_9 M5:GATE RESET:11 5.05051
R3_10 M5:GATE RESET:10 5.05051
R3_11 RESET:6 RESET:24 8.08081
R3_12 RESET:7 RESET:8 26.2626
R3_13 RESET:9 RESET:18 9.44444
R3_14 RESET:10 RESET:25 8.08081
R3_15 RESET:11 RESET:12 26.2626
R3_16 RESET:13 RESET:20 9.44444
R3_17 RESET:14 RESET:15 63.5281
R3_18 RESET:14 RESET:23 3.72918
R3_19 RESET:14 RESET:16 78.3128
R3_20 RESET:15 RESET:21 3.58332
R3_21 RESET:16 RESET:17 63.5281
R3_22 RESET:16 RESET:27 3.72918
R3_23 RESET:17 RESET:22 3.58332
R3_24 RESET:17 RESET:19 50.1665
R3_25 RESET:19 RESET:20 63.5281
R3_26 RESET:19 RESET:26 3.58332

*|NET VSS 0.000345803PF
*|P (VSS B 0 0.5040 0.0000)
*|I (M1:SRC M1 SRC B 0 0.9600 0.0360)
*|I (M10:DRN M10 DRN B 0 0.4260 0.0360)
*|I (M11:SRC M11 SRC B 0 0.3720 0.0360)
*|I (M14:SRC M14 SRC B 0 0.1620 0.0360)
*|I (M15:SRC M15 SRC B 0 0.0780 0.0360)
*|I (M16:DRN M16 DRN B 0 0.0480 0.0360)
*|I (M3:DRN M3 DRN B 0 0.8040 0.0360)
*|I (M4:SRC M4 SRC B 0 0.7500 0.0360)
*|I (M5:DRN M5 DRN B 0 0.7200 0.0360)
*|I (M6:SRC M6 SRC B 0 0.6660 0.0360)
*|I (M8:DRN M8 DRN B 0 0.5100 0.0360)
*|I (M9:SRC M9 SRC B 0 0.4560 0.0360)
C4_1 VSS:62 CK:6 4.5988e-19
C4_2 VSS:75 CK:6 4.87154e-21
C4_3 VSS:76 CK:6 4.87154e-21
C4_4 VSS:62 CK:7 7.89427e-21
C4_5 VSS:62 CK:10 4.59524e-19
C4_6 VSS:62 CK:11 7.89427e-21
C4_7 VSS:20 CK:14 9.90405e-20
C4_8 VSS:65 CK:14 8.20537e-21
C4_9 VSS:14 CK:23 1.9089e-20
C4_10 VSS:20 CK:23 2.26678e-19
C4_11 VSS:62 CK:23 7.69095e-20
C4_12 VSS:65 CK:23 3.25323e-19
C4_13 VSS:66 CK:23 8.42159e-20
C4_14 VSS:75 CK:23 7.57214e-19
C4_15 VSS:76 CK:23 7.57214e-19
C4_16 VSS:65 CK:24 2.65126e-19
C4_17 VSS:75 CK:24 5.08618e-20
C4_18 VSS:76 CK:24 5.08618e-20
C4_19 VSS:65 CK:25 6.49545e-20
C4_20 VSS:75 CK:25 4.0138e-20
C4_21 VSS:76 CK:25 4.0138e-20
C4_22 VSS:62 SET:16 8.29682e-19
C4_23 VSS:62 SET:18 8.29682e-19
C4_24 VSS:38 SET:19 2.35501e-19
C4_25 VSS:62 SET:19 2.13859e-19
C4_26 VSS:69 SET:19 2.48548e-19
C4_27 VSS:70 SET:19 2.29751e-20
C4_28 VSS:75 SET:19 1.9567e-18
C4_29 VSS:76 SET:19 1.9567e-18
C4_30 VSS:84 SET:19 1.28376e-19
C4_31 VSS:48 SET:20 6.81616e-19
C4_32 VSS:52 SET:20 6.83983e-19
C4_33 VSS:62 SET:20 6.01171e-19
C4_34 VSS:71 SET:20 3.4232e-19
C4_35 VSS:75 SET:20 4.6649e-18
C4_36 VSS:76 SET:20 4.6649e-18
C4_37 VSS:85 SET:20 2.82538e-19
C4_38 VSS:86 SET:20 3.15028e-19
C4_39 VSS:38 SET:21 4.6014e-21
C4_40 VSS:42 SET:21 3.93108e-20
C4_41 VSS:69 SET:21 2.19795e-20
C4_42 VSS:70 SET:21 3.92181e-20
C4_43 VSS:71 SET:21 1.52381e-20
C4_44 VSS:75 SET:21 1.43397e-18
C4_45 VSS:76 SET:21 1.43397e-18
C4_46 VSS:84 SET:21 2.79113e-21
Cg4_47 VSS:14 VSS 2.7516e-19
Cg4_48 VSS:15 VSS 2.84101e-19
Cg4_49 VSS:16 VSS 1.90317e-19
Cg4_50 VSS:20 VSS 4.84128e-19
Cg4_51 VSS:24 VSS 5.55612e-19
Cg4_52 VSS:34 VSS 1.58831e-19
Cg4_53 VSS:38 VSS 1.35755e-19
Cg4_54 VSS:42 VSS 1.21185e-19
Cg4_55 VSS:48 VSS 1.59309e-19
Cg4_56 VSS:52 VSS 1.58831e-19
Cg4_57 VSS:56 VSS 7.14837e-20
Cg4_58 VSS:62 VSS 8.39911e-18
Cg4_59 VSS:65 VSS 4.03912e-17
Cg4_60 VSS:68 VSS 3.11065e-18
Cg4_61 VSS:69 VSS 2.52851e-17
Cg4_62 VSS:70 VSS 9.89812e-20
Cg4_63 VSS:71 VSS 3.6958e-17
Cg4_64 VSS:72 VSS 2.33232e-17
Cg4_65 VSS:74 VSS 2.58088e-18
Cg4_66 VSS:75 VSS 1.28006e-17
Cg4_67 VSS:76 VSS 1.28006e-17
Cg4_68 VSS:83 VSS 1.64651e-19
Cg4_69 VSS:84 VSS 1.29936e-19
Cg4_70 VSS:85 VSS 1.47716e-19
Cg4_71 VSS:86 VSS 1.47716e-19
Cg4_72 VSS:87 VSS 1.2262e-19
R4_1 VSS VSS:41 12.5416
R4_2 VSS VSS:39 12.5416
R4_3 M1:SRC VSS:73 30000.0
R4_4 M1:SRC VSS:16 30000.0
R4_5 M1:SRC VSS:88 15000.0
R4_6 M10:DRN VSS:91 45000.0
R4_7 M10:DRN VSS:84 32142.8
R4_8 M10:DRN VSS:90 28125.0
R4_9 M11:SRC VSS:83 14437.9
R4_10 M14:SRC VSS:67 30000.0
R4_11 M14:SRC VSS:15 30000.0
R4_12 M14:SRC VSS:81 15000.0
R4_13 M15:SRC VSS:66 30000.0
R4_14 M15:SRC VSS:14 30000.0
R4_15 M15:SRC VSS:79 15000.0
R4_16 M16:DRN VSS:66 30000.0
R4_17 M16:DRN VSS:14 30000.0
R4_18 M16:DRN VSS:79 15000.0
R4_19 M3:DRN VSS:87 14233.3
R4_20 M4:SRC VSS:93 45000.0
R4_21 M4:SRC VSS:86 32142.8
R4_22 M4:SRC VSS:92 28125.0
R4_23 M5:DRN VSS:93 45000.0
R4_24 M5:DRN VSS:86 32142.8
R4_25 M5:DRN VSS:92 28125.0
R4_26 M6:SRC VSS:85 14233.3
R4_27 M8:DRN VSS:70 13327.0
R4_28 M9:SRC VSS:91 45000.0
R4_29 M9:SRC VSS:84 32142.8
R4_30 M9:SRC VSS:90 28125.0
R4_31 VSS:14 VSS:79 7.84041
R4_32 VSS:14 VSS:20 12.4587
R4_33 VSS:15 VSS:81 7.8411
R4_34 VSS:15 VSS:24 12.4587
R4_35 VSS:16 VSS:88 7.8411
R4_36 VSS:16 VSS:62 12.4587
R4_37 VSS:17 VSS:18 63.5281
R4_38 VSS:17 VSS:75 17.9166
R4_39 VSS:17 VSS:19 25.0832
R4_40 VSS:18 VSS:77 39.6198
R4_41 VSS:18 VSS:20 50.1851
R4_42 VSS:19 VSS:20 31.764
R4_43 VSS:19 VSS:21 25.0832
R4_44 VSS:20 VSS:22 50.1851
R4_45 VSS:21 VSS:22 63.5281
R4_46 VSS:21 VSS:23 25.0832
R4_47 VSS:22 VSS:24 50.1851
R4_48 VSS:23 VSS:24 31.764
R4_49 VSS:23 VSS:25 25.0832
R4_50 VSS:24 VSS:26 50.1851
R4_51 VSS:25 VSS:26 63.5281
R4_52 VSS:25 VSS:27 25.0832
R4_53 VSS:26 VSS:28 55.4677
R4_54 VSS:27 VSS:28 63.5281
R4_55 VSS:27 VSS:29 25.0832
R4_56 VSS:28 VSS:30 55.4677
R4_57 VSS:29 VSS:30 63.5281
R4_58 VSS:29 VSS:31 25.0832
R4_59 VSS:30 VSS:32 55.4677
R4_60 VSS:31 VSS:32 63.5281
R4_61 VSS:31 VSS:33 25.0832
R4_62 VSS:32 VSS:34 50.1851
R4_63 VSS:33 VSS:34 31.764
R4_64 VSS:33 VSS:35 25.0832
R4_65 VSS:34 VSS:36 50.1851
R4_66 VSS:34 VSS:83 14.2385
R4_67 VSS:35 VSS:36 63.5281
R4_68 VSS:35 VSS:37 25.0832
R4_69 VSS:36 VSS:38 50.1851
R4_70 VSS:37 VSS:38 31.764
R4_71 VSS:37 VSS:39 25.0832
R4_72 VSS:38 VSS:40 50.1851
R4_73 VSS:38 VSS:84 13.3486
R4_74 VSS:39 VSS:40 63.5281
R4_75 VSS:40 VSS:42 50.1851
R4_76 VSS:41 VSS:42 31.764
R4_77 VSS:41 VSS:43 25.0832
R4_78 VSS:42 VSS:70 16.3796
R4_79 VSS:42 VSS:44 50.1851
R4_80 VSS:43 VSS:44 63.5281
R4_81 VSS:43 VSS:45 25.0832
R4_82 VSS:44 VSS:46 55.4677
R4_83 VSS:45 VSS:46 63.5281
R4_84 VSS:45 VSS:47 25.0832
R4_85 VSS:46 VSS:48 50.1851
R4_86 VSS:47 VSS:48 31.764
R4_87 VSS:47 VSS:49 25.0832
R4_88 VSS:48 VSS:50 50.1851
R4_89 VSS:48 VSS:85 14.8318
R4_90 VSS:49 VSS:50 63.5281
R4_91 VSS:49 VSS:51 25.0832
R4_92 VSS:50 VSS:52 50.1851
R4_93 VSS:51 VSS:52 31.764
R4_94 VSS:51 VSS:53 25.0832
R4_95 VSS:52 VSS:54 50.1851
R4_96 VSS:52 VSS:86 14.8318
R4_97 VSS:53 VSS:54 63.5281
R4_98 VSS:53 VSS:55 25.0832
R4_99 VSS:54 VSS:56 50.1851
R4_100 VSS:55 VSS:56 31.764
R4_101 VSS:55 VSS:57 25.0832
R4_102 VSS:56 VSS:58 50.1851
R4_103 VSS:56 VSS:87 14.8318
R4_104 VSS:57 VSS:58 63.5281
R4_105 VSS:57 VSS:59 25.0832
R4_106 VSS:58 VSS:60 55.4677
R4_107 VSS:59 VSS:60 63.5281
R4_108 VSS:59 VSS:61 25.0832
R4_109 VSS:60 VSS:62 50.1851
R4_110 VSS:61 VSS:62 31.764
R4_111 VSS:61 VSS:63 25.0832
R4_112 VSS:62 VSS:64 50.1851
R4_113 VSS:63 VSS:64 63.5281
R4_114 VSS:63 VSS:76 17.9166
R4_115 VSS:64 VSS:78 39.6198
R4_116 VSS:65 VSS:68 7352.43
R4_117 VSS:66 VSS:79 7.84041
R4_118 VSS:66 VSS:80 1.77981
R4_119 VSS:67 VSS:81 7.8411
R4_120 VSS:67 VSS:82 1.77981
R4_121 VSS:68 VSS:69 3155.49
R4_122 VSS:69 VSS:71 9557.92
R4_123 VSS:71 VSS:72 9557.92
R4_124 VSS:72 VSS:74 6119.35
R4_125 VSS:73 VSS:88 7.8411
R4_126 VSS:73 VSS:89 1.77981
R4_127 VSS:84 VSS:90 8100.0
R4_128 VSS:86 VSS:92 6600.0
R4_129 VSS:90 VSS:91 6000.0
R4_130 VSS:92 VSS:93 6000.0
R4_131 VSS:69 VSS:34 0.01

*|NET VDD 0.000198277PF
*|P (VDD B 0 0.5040 0.1440)
*|I (M17:SRC M17 SRC B 0 0.9600 0.1080)
*|I (M20:SRC M20 SRC B 0 0.7500 0.1080)
*|I (M21:DRN M21 DRN B 0 0.7200 0.1080)
*|I (M25:SRC M25 SRC B 0 0.4560 0.1080)
*|I (M26:DRN M26 DRN B 0 0.4260 0.1080)
*|I (M30:SRC M30 SRC B 0 0.1620 0.1080)
*|I (M31:SRC M31 SRC B 0 0.0780 0.1080)
*|I (M32:DRN M32 DRN B 0 0.0480 0.1080)
C5_1 VDD:12 CK:9 1.15294e-19
C5_2 VDD:67 CK:9 2.18322e-20
C5_3 VDD:68 CK:9 2.18322e-20
C5_4 VDD:12 CK:13 1.15459e-19
C5_5 VDD:67 CK:13 1.26476e-20
C5_6 VDD:68 CK:13 1.26476e-20
C5_7 VDD:19 CK:14 5.16469e-19
C5_8 VDD:62 CK:14 4.925e-21
C5_9 VDD:13 CK:23 2.03074e-20
C5_10 VDD:19 CK:23 1.0838e-19
C5_11 VDD:62 CK:23 8.21522e-20
C5_12 VDD:67 CK:23 9.59379e-19
C5_13 VDD:68 CK:23 9.59379e-19
C5_14 VDD:67 CK:24 9.3914e-19
C5_15 VDD:68 CK:24 9.3914e-19
C5_16 VDD:13 CK:25 2.35748e-20
C5_17 VDD:19 CK:25 3.0827e-20
C5_18 VDD:23 CK:25 3.06999e-21
C5_19 VDD:62 CK:25 1.77149e-20
C5_20 VDD:64 CK:25 3.93663e-21
C5_21 VDD:67 CK:25 2.35717e-18
C5_22 VDD:68 CK:25 2.35717e-18
C5_23 VDD:12 RESET:9 1.15837e-19
C5_24 VDD:67 RESET:9 2.10658e-20
C5_25 VDD:68 RESET:9 2.10658e-20
C5_26 VDD:12 RESET:13 1.15837e-19
C5_27 VDD:67 RESET:13 2.10658e-20
C5_28 VDD:68 RESET:13 2.10658e-20
C5_29 VDD:12 RESET:18 7.65202e-19
C5_30 VDD:67 RESET:18 2.50858e-20
C5_31 VDD:68 RESET:18 2.50858e-20
C5_32 VDD:12 RESET:20 7.65202e-19
C5_33 VDD:67 RESET:20 2.50858e-20
C5_34 VDD:68 RESET:20 2.50858e-20
C5_35 VDD:10 RESET:21 3.13388e-19
C5_36 VDD:67 RESET:21 3.37485e-18
C5_37 VDD:68 RESET:21 3.37485e-18
C5_38 VDD:75 RESET:21 2.29803e-19
C5_39 VDD:12 RESET:22 3.5199e-20
C5_40 VDD:67 RESET:22 3.35595e-18
C5_41 VDD:68 RESET:22 3.35595e-18
C5_42 VDD:76 RESET:22 1.40258e-20
C5_43 VDD:10 RESET:23 4.6014e-21
C5_44 VDD:67 RESET:23 1.57504e-18
C5_45 VDD:68 RESET:23 1.57504e-18
C5_46 VDD:75 RESET:23 3.95932e-21
C5_47 VDD:19 VSS:20 3.45688e-19
C5_48 VDD:62 VSS:20 2.25894e-20
C5_49 VDD:67 VSS:20 1.51604e-20
C5_50 VDD:68 VSS:20 1.51604e-20
C5_51 VDD:23 VSS:24 1.20446e-19
C5_52 VDD:64 VSS:24 3.86285e-21
C5_53 VDD:67 VSS:24 4.39458e-22
C5_54 VDD:68 VSS:24 4.39458e-22
C5_55 VDD:75 VSS:38 2.13416e-20
C5_56 VDD:76 VSS:52 8.67191e-21
C5_57 VDD:12 VSS:62 1.75714e-19
C5_58 VDD:23 VSS:62 6.86128e-20
C5_59 VDD:64 VSS:62 6.70874e-21
C5_60 VDD:65 VSS:62 4.01983e-21
C5_61 VDD:67 VSS:62 3.90331e-20
C5_62 VDD:68 VSS:62 3.90331e-20
C5_63 VDD:13 VSS:65 8.04144e-19
C5_64 VDD:14 VSS:65 8.03898e-19
C5_65 VDD:19 VSS:65 1.50654e-18
C5_66 VDD:23 VSS:65 1.50257e-18
C5_67 VDD:67 VSS:65 9.1533e-19
C5_68 VDD:68 VSS:65 9.1533e-19
C5_69 VDD:67 VSS:68 1.04225e-19
C5_70 VDD:68 VSS:68 1.04225e-19
C5_71 VDD:10 VSS:69 9.41552e-19
C5_72 VDD:67 VSS:69 5.51292e-19
C5_73 VDD:68 VSS:69 5.51292e-19
C5_74 VDD:75 VSS:69 4.11727e-19
C5_75 VDD:11 VSS:71 9.48773e-19
C5_76 VDD:67 VSS:71 9.43221e-19
C5_77 VDD:68 VSS:71 9.43221e-19
C5_78 VDD:76 VSS:71 2.73625e-19
C5_79 VDD:12 VSS:72 3.57171e-19
C5_80 VDD:67 VSS:72 4.62361e-19
C5_81 VDD:68 VSS:72 4.62361e-19
C5_82 VDD:12 VSS:75 1.38141e-20
C5_83 VDD:67 VSS:75 9.45063e-19
C5_84 VDD:12 VSS:76 1.38141e-20
C5_85 VDD:68 VSS:76 9.45063e-19
C5_86 VDD:75 VSS:84 1.22073e-20
C5_87 VDD:76 VSS:86 1.21215e-20
Cg5_88 VDD:10 VSS 7.5472e-19
Cg5_89 VDD:11 VSS 6.23427e-19
Cg5_90 VDD:12 VSS 4.68456e-17
Cg5_91 VDD:13 VSS 2.69457e-19
Cg5_92 VDD:14 VSS 2.96753e-19
Cg5_93 VDD:15 VSS 1.90317e-19
Cg5_94 VDD:19 VSS 8.67766e-19
Cg5_95 VDD:23 VSS 8.33447e-19
Cg5_96 VDD:64 VSS 5.43919e-21
Cg5_97 VDD:65 VSS 5.43766e-21
Cg5_98 VDD:67 VSS 1.33812e-17
Cg5_99 VDD:68 VSS 1.33812e-17
Cg5_100 VDD:75 VSS 2.07108e-19
Cg5_101 VDD:76 VSS 1.2399e-19
R5_1 VDD VDD:63 0.1
R5_2 VDD VDD:39 12.5416
R5_3 VDD VDD:37 12.5416
R5_4 M17:SRC VDD:65 30000.0
R5_5 M17:SRC VDD:15 30000.0
R5_6 M17:SRC VDD:77 15000.0
R5_7 M20:SRC VDD:76 32142.8
R5_8 M20:SRC VDD:81 45000.0
R5_9 M20:SRC VDD:82 28125.0
R5_10 M21:DRN VDD:76 32142.8
R5_11 M21:DRN VDD:81 45000.0
R5_12 M21:DRN VDD:82 28125.0
R5_13 M25:SRC VDD:75 32142.8
R5_14 M25:SRC VDD:79 45000.0
R5_15 M25:SRC VDD:80 28125.0
R5_16 M26:DRN VDD:75 32142.8
R5_17 M26:DRN VDD:79 45000.0
R5_18 M26:DRN VDD:80 28125.0
R5_19 M30:SRC VDD:64 30000.0
R5_20 M30:SRC VDD:14 30000.0
R5_21 M30:SRC VDD:73 15000.0
R5_22 M31:SRC VDD:62 30000.0
R5_23 M31:SRC VDD:13 30000.0
R5_24 M31:SRC VDD:71 15000.0
R5_25 M32:DRN VDD:62 30000.0
R5_26 M32:DRN VDD:13 30000.0
R5_27 M32:DRN VDD:71 15000.0
R5_28 VDD:10 VDD:35 50.1851
R5_29 VDD:10 VDD:36 31.764
R5_30 VDD:10 VDD:75 13.3486
R5_31 VDD:10 VDD:38 50.1851
R5_32 VDD:11 VDD:48 50.1851
R5_33 VDD:11 VDD:49 31.764
R5_34 VDD:11 VDD:76 14.8318
R5_35 VDD:11 VDD:51 50.1851
R5_36 VDD:12 VDD:65 12.4587
R5_37 VDD:12 VDD:57 50.1851
R5_38 VDD:12 VDD:58 31.764
R5_39 VDD:12 VDD:60 50.1851
R5_40 VDD:13 VDD:71 7.84041
R5_41 VDD:13 VDD:72 1.77981
R5_42 VDD:14 VDD:73 7.8411
R5_43 VDD:14 VDD:74 1.77981
R5_44 VDD:15 VDD:77 7.8411
R5_45 VDD:15 VDD:78 1.77981
R5_46 VDD:16 VDD:17 63.5281
R5_47 VDD:16 VDD:67 17.9166
R5_48 VDD:16 VDD:18 25.0832
R5_49 VDD:17 VDD:69 39.6198
R5_50 VDD:17 VDD:19 50.1851
R5_51 VDD:18 VDD:19 31.764
R5_52 VDD:18 VDD:20 25.0832
R5_53 VDD:19 VDD:62 12.4587
R5_54 VDD:19 VDD:21 50.1851
R5_55 VDD:20 VDD:21 63.5281
R5_56 VDD:20 VDD:22 25.0832
R5_57 VDD:21 VDD:23 50.1851
R5_58 VDD:22 VDD:23 31.764
R5_59 VDD:22 VDD:24 25.0832
R5_60 VDD:23 VDD:25 50.1851
R5_61 VDD:23 VDD:64 12.4587
R5_62 VDD:24 VDD:25 63.5281
R5_63 VDD:24 VDD:26 25.0832
R5_64 VDD:25 VDD:27 55.4677
R5_65 VDD:26 VDD:27 63.5281
R5_66 VDD:26 VDD:28 25.0832
R5_67 VDD:27 VDD:29 55.4677
R5_68 VDD:28 VDD:29 63.5281
R5_69 VDD:28 VDD:30 25.0832
R5_70 VDD:29 VDD:31 55.4677
R5_71 VDD:30 VDD:31 63.5281
R5_72 VDD:30 VDD:32 25.0832
R5_73 VDD:31 VDD:33 55.4677
R5_74 VDD:32 VDD:33 63.5281
R5_75 VDD:32 VDD:34 25.0832
R5_76 VDD:33 VDD:35 55.4677
R5_77 VDD:34 VDD:35 63.5281
R5_78 VDD:34 VDD:36 25.0832
R5_79 VDD:36 VDD:37 25.0832
R5_80 VDD:37 VDD:38 63.5281
R5_81 VDD:38 VDD:40 55.4677
R5_82 VDD:39 VDD:40 63.5281
R5_83 VDD:39 VDD:41 25.0832
R5_84 VDD:40 VDD:42 55.4677
R5_85 VDD:41 VDD:42 63.5281
R5_86 VDD:41 VDD:43 25.0832
R5_87 VDD:42 VDD:44 55.4677
R5_88 VDD:43 VDD:44 63.5281
R5_89 VDD:43 VDD:45 25.0832
R5_90 VDD:44 VDD:46 55.4677
R5_91 VDD:45 VDD:46 63.5281
R5_92 VDD:45 VDD:47 25.0832
R5_93 VDD:46 VDD:48 55.4677
R5_94 VDD:47 VDD:48 63.5281
R5_95 VDD:47 VDD:49 25.0832
R5_96 VDD:49 VDD:50 25.0832
R5_97 VDD:50 VDD:51 63.5281
R5_98 VDD:50 VDD:52 25.0832
R5_99 VDD:51 VDD:53 55.4677
R5_100 VDD:52 VDD:53 63.5281
R5_101 VDD:52 VDD:54 25.0832
R5_102 VDD:53 VDD:55 55.4677
R5_103 VDD:54 VDD:55 63.5281
R5_104 VDD:54 VDD:56 25.0832
R5_105 VDD:55 VDD:57 55.4677
R5_106 VDD:56 VDD:57 63.5281
R5_107 VDD:56 VDD:58 25.0832
R5_108 VDD:58 VDD:59 25.0832
R5_109 VDD:59 VDD:60 63.5281
R5_110 VDD:59 VDD:68 17.9166
R5_111 VDD:60 VDD:70 39.6198
R5_112 VDD:61 VDD:63 21488.6
R5_113 VDD:62 VDD:71 7.84041
R5_114 VDD:63 VDD:66 169833.0
R5_115 VDD:64 VDD:73 7.8411
R5_116 VDD:65 VDD:77 7.8411
R5_117 VDD:75 VDD:80 8100.0
R5_118 VDD:76 VDD:82 6600.0
R5_119 VDD:79 VDD:80 6000.0
R5_120 VDD:81 VDD:82 6000.0

*|NET D 2.11807e-05PF
*|P (D B 0 0.1470 0.0720)
*|I (M14:GATE M14 GATE I 3.6e-19 0.1680 0.0360)
*|I (M30:GATE M30 GATE I 3.6e-19 0.1680 0.1080)
C6_1 D:11 CK:23 2.48837e-19
C6_2 D:11 CK:24 6.14561e-19
C6_3 D:7 CK:25 1.71389e-20
C6_4 D:11 CK:25 1.13056e-18
C6_5 D:11 VSS:15 2.51906e-19
C6_6 D:9 VSS:24 9.16124e-19
C6_7 D:11 VSS:24 6.13218e-19
C6_8 D:4 VSS:62 4.61602e-19
C6_9 D:5 VSS:62 7.89427e-21
C6_10 D:11 VSS:62 9.63817e-20
C6_11 D:11 VSS:65 5.43197e-19
C6_12 D:11 VSS:67 4.52208e-20
C6_13 D:4 VSS:75 1.0364e-20
C6_14 D:11 VSS:75 7.21519e-19
C6_15 D:4 VSS:76 1.0364e-20
C6_16 D:11 VSS:76 7.21519e-19
C6_17 D:8 VDD:12 1.15802e-19
C6_18 D:11 VDD:14 1.1494e-19
C6_19 D:9 VDD:23 1.58128e-18
C6_20 D:11 VDD:23 4.71132e-19
C6_21 D:9 VDD:64 1.48933e-20
C6_22 D:11 VDD:64 1.08488e-19
C6_23 D:4 VDD:67 2.01272e-21
C6_24 D:8 VDD:67 1.96391e-20
C6_25 D:9 VDD:67 1.41512e-20
C6_26 D:11 VDD:67 6.89691e-19
C6_27 D:4 VDD:68 2.01272e-21
C6_28 D:8 VDD:68 1.96391e-20
C6_29 D:9 VDD:68 1.41512e-20
C6_30 D:11 VDD:68 6.89691e-19
Cg6_31 D:4 VSS 1.09486e-19
Cg6_32 D:6 VSS 3.4119e-19
Cg6_33 D:8 VSS 2.31874e-19
Cg6_34 D:9 VSS 1.99342e-19
Cg6_35 D:11 VSS 2.24979e-18
R6_1 D D:11 29.3832
R6_2 D D:14 29.4429
R6_3 D D:10 63.5281
R6_4 M14:GATE D:5 7.57576
R6_5 M14:GATE D:4 7.57576
R6_6 M30:GATE D:7 7.57576
R6_7 M30:GATE D:6 7.57576
R6_8 D:4 D:12 5.55556
R6_9 D:5 D:9 10.6061
R6_10 D:6 D:9 10.6061
R6_11 D:7 D:8 5.55556
R6_12 D:9 D:10 27.7339
R6_13 D:10 D:13 7.92396

*|NET QN 1.67194e-05PF
*|P (QN B 0 0.9870 0.0720)
*|I (M1:DRN M1 DRN B 0 0.9720 0.0360)
*|I (M17:DRN M17 DRN B 0 0.9720 0.1080)
C7_1 M1:DRN VSS:16 3.78986e-20
C7_2 QN:12 VSS:16 1.77132e-19
C7_3 M1:DRN VSS:62 5.11785e-20
C7_4 QN:4 VSS:62 2.32339e-18
C7_5 QN:12 VSS:62 1.88848e-19
C7_6 QN:12 VSS:72 6.36888e-19
C7_7 QN:12 VSS:74 1.55906e-19
C7_8 QN:4 VSS:75 4.43303e-20
C7_9 QN:12 VSS:75 7.46294e-19
C7_10 QN:4 VSS:76 4.43303e-20
C7_11 QN:12 VSS:76 7.46294e-19
C7_12 M17:DRN VDD:12 3.81728e-20
C7_13 QN:5 VDD:12 1.05946e-18
C7_14 QN:12 VDD:12 1.14371e-19
C7_15 M17:DRN VDD:15 3.78986e-20
C7_16 QN:12 VDD:15 1.77132e-19
C7_17 QN:5 VDD:67 1.15284e-19
C7_18 QN:12 VDD:67 7.47479e-19
C7_19 QN:5 VDD:68 1.15284e-19
C7_20 QN:12 VDD:68 7.47479e-19
Cg7_21 QN:4 VSS 2.89834e-19
Cg7_22 QN:5 VSS 2.8933e-19
Cg7_23 QN:6 VSS 1.78742e-19
Cg7_24 QN:7 VSS 1.78742e-19
Cg7_25 QN:12 VSS 3.43398e-18
R7_1 QN QN:10 21.4999
R7_2 QN QN:8 21.4999
R7_3 M1:DRN QN:6 30000.0
R7_4 M1:DRN QN:4 30000.0
R7_5 M1:DRN QN:9 15000.0
R7_6 M17:DRN QN:7 30000.0
R7_7 M17:DRN QN:5 30000.0
R7_8 M17:DRN QN:11 15000.0
R7_9 QN:4 QN:9 9.78801
R7_10 QN:5 QN:11 9.78801
R7_11 QN:6 QN:9 9.78801
R7_12 QN:7 QN:11 9.78801
R7_13 QN:8 QN:9 63.5281
R7_14 QN:8 QN:12 7.8833
R7_15 QN:10 QN:11 63.5281
R7_16 QN:10 QN:13 7.94303

*|NET 11 7.32451e-05PF
*|I (M12:SRC M12 SRC B 0 0.2460 0.0285)
*|I (M13:DRN M13 DRN B 0 0.2160 0.0360)
*|I (M24:GATE M24 GATE I 2.4e-19 0.5040 0.1080)
*|I (M28:SRC M28 SRC B 0 0.2880 0.1155)
*|I (M29:DRN M29 DRN B 0 0.2580 0.1080)
*|I (M8:GATE M8 GATE I 2.4e-19 0.5040 0.0360)
C9_1 11:22 CK:10 2.94507e-20
C9_2 11:22 CK:11 5.61249e-20
C9_3 11:22 CK:12 7.44544e-20
C9_4 M29:DRN CK:15 6.08084e-21
C9_5 11:12 CK:15 8.34054e-19
C9_6 11:12 CK:24 3.2445e-19
C9_7 11:22 CK:24 7.72583e-19
C9_8 11:23 CK:24 1.5268e-18
C9_9 11:24 CK:24 7.08839e-19
C9_10 11:25 CK:24 2.21548e-20
C9_11 11:23 CK:25 2.46254e-20
C9_12 11:24 CK:25 3.59564e-19
C9_13 11:25 CK:25 9.56151e-21
C9_14 11:25 RESET:8 1.25056e-19
C9_15 11:10 RESET:21 2.19919e-20
C9_16 11:11 RESET:21 3.34214e-20
C9_17 11:14 RESET:21 6.58373e-20
C9_18 11:17 RESET:21 1.72515e-18
C9_19 11:23 RESET:21 2.44341e-21
C9_20 11:24 RESET:21 6.43569e-19
C9_21 11:25 RESET:21 4.21503e-18
C9_22 11:11 RESET:23 2.41953e-36
C9_23 11:24 RESET:23 7.05083e-20
C9_24 11:25 RESET:23 8.53014e-21
C9_25 M13:DRN VSS:62 2.08288e-20
C9_26 11:7 VSS:62 4.59992e-19
C9_27 11:8 VSS:62 7.89427e-21
C9_28 11:12 VSS:62 2.32373e-18
C9_29 11:22 VSS:62 2.01589e-19
C9_30 11:12 VSS:65 7.23562e-19
C9_31 11:13 VSS:65 3.42049e-19
C9_32 11:15 VSS:65 3.99684e-19
C9_33 11:16 VSS:65 3.99872e-19
C9_34 11:22 VSS:65 2.41948e-19
C9_35 11:23 VSS:65 3.43722e-19
C9_36 11:24 VSS:65 2.17765e-19
C9_37 11:24 VSS:68 1.53982e-19
C9_38 11:25 VSS:68 5.61261e-20
C9_39 11:14 VSS:69 1.24645e-20
C9_40 11:17 VSS:69 7.2145e-20
C9_41 11:24 VSS:69 2.50812e-20
C9_42 11:25 VSS:69 7.61094e-19
C9_43 11:7 VSS:75 2.14113e-36
C9_44 11:12 VSS:75 1.53946e-20
C9_45 11:22 VSS:75 2.04503e-18
C9_46 11:23 VSS:75 3.09264e-20
C9_47 11:24 VSS:75 1.46691e-19
C9_48 11:25 VSS:75 8.16377e-20
C9_49 11:7 VSS:76 2.14113e-36
C9_50 11:12 VSS:76 1.53946e-20
C9_51 11:22 VSS:76 2.04503e-18
C9_52 11:23 VSS:76 3.09264e-20
C9_53 11:24 VSS:76 1.46691e-19
C9_54 11:25 VSS:76 8.16377e-20
C9_55 11:25 VSS:83 3.58631e-20
C9_56 11:25 VSS:84 6.53511e-20
C9_57 11:11 VDD:12 1.15837e-19
C9_58 11:13 VDD:12 1.06277e-18
C9_59 11:11 VDD:67 2.10658e-20
C9_60 11:13 VDD:67 6.91364e-20
C9_61 11:17 VDD:67 4.15897e-20
C9_62 11:22 VDD:67 1.16141e-19
C9_63 11:23 VDD:67 4.67866e-20
C9_64 11:24 VDD:67 3.5039e-18
C9_65 11:25 VDD:67 6.82678e-19
C9_66 11:11 VDD:68 2.10658e-20
C9_67 11:13 VDD:68 6.91364e-20
C9_68 11:17 VDD:68 4.15897e-20
C9_69 11:22 VDD:68 1.16141e-19
C9_70 11:23 VDD:68 4.67866e-20
C9_71 11:24 VDD:68 3.5039e-18
C9_72 11:25 VDD:68 6.82678e-19
C9_73 11:25 VDD:75 1.15582e-20
Cg9_74 M29:DRN VSS 4.96264e-20
Cg9_75 11:7 VSS 1.92161e-19
Cg9_76 11:8 VSS 2.22446e-20
Cg9_77 11:9 VSS 4.22426e-19
Cg9_78 11:11 VSS 2.67751e-19
Cg9_79 11:12 VSS 3.22699e-19
Cg9_80 11:13 VSS 2.62365e-19
Cg9_81 11:14 VSS 1.80334e-19
Cg9_82 11:15 VSS 2.08688e-19
Cg9_83 11:16 VSS 2.08984e-19
Cg9_84 11:17 VSS 5.31176e-19
Cg9_85 11:22 VSS 1.06884e-18
Cg9_86 11:23 VSS 1.29315e-18
Cg9_87 11:24 VSS 1.06881e-18
Cg9_88 11:25 VSS 1.55863e-18
R9_1 M12:SRC 11:12 59210.5
R9_2 M12:SRC 11:29 57692.3
R9_3 M12:SRC 11:28 62500.0
R9_4 M12:SRC 11:20 60810.8
R9_5 M13:DRN 11:15 30000.0
R9_6 M13:DRN 11:28 20270.3
R9_7 M13:DRN 11:29 57692.3
R9_8 M13:DRN 11:12 59210.5
R9_9 M13:DRN 11:20 60810.8
R9_10 M24:GATE 11:10 5.05051
R9_11 M24:GATE 11:9 5.05051
R9_12 M28:SRC 11:16 60810.8
R9_13 M28:SRC 11:31 57692.3
R9_14 M28:SRC 11:30 60810.8
R9_15 M28:SRC 11:21 60810.8
R9_16 M29:DRN 11:13 30000.0
R9_17 M29:DRN 11:30 20089.3
R9_18 M29:DRN 11:21 60810.8
R9_19 M29:DRN 11:16 60810.8
R9_20 M29:DRN 11:31 57692.3
R9_21 M8:GATE 11:8 5.05051
R9_22 M8:GATE 11:7 5.05051
R9_23 11:7 11:26 8.08081
R9_24 11:8 11:14 20.4545
R9_25 11:9 11:14 5.80808
R9_26 11:10 11:11 8.08081
R9_27 11:12 11:20 5.51743
R9_28 11:12 11:29 4.70425
R9_29 11:13 11:30 8.62521
R9_30 11:13 11:21 14.1199
R9_31 11:14 11:18 27.7339
R9_32 11:15 11:20 14.0605
R9_33 11:15 11:28 98999.9
R9_34 11:16 11:21 5.4581
R9_35 11:16 11:31 27000.0
R9_36 11:17 11:18 63.5281
R9_37 11:17 11:25 51.6925
R9_38 11:18 11:27 7.92396
R9_39 11:19 11:20 63.5281
R9_40 11:19 11:32 3.58332
R9_41 11:19 11:22 25.0832
R9_42 11:20 11:28 3.7634
R9_43 11:20 11:29 900.0
R9_44 11:21 11:31 0.104539
R9_45 11:21 11:30 21900.0
R9_46 11:21 11:23 63.5281
R9_47 11:22 11:23 49.8679
R9_48 11:23 11:24 50.1665
R9_49 11:24 11:25 16.6027

*|NET 12 3.40011e-05PF
*|I (M10:SRC M10 SRC B 0 0.4140 0.0360)
*|I (M11:DRN M11 DRN B 0 0.3840 0.0360)
*|I (M12:DRN M12 DRN B 0 0.2580 0.0285)
C10_1 M11:DRN VSS:34 6.41463e-21
C10_2 12:10 VSS:34 6.81861e-19
C10_3 M11:DRN VSS:62 2.02063e-20
C10_4 M12:DRN VSS:62 2.01707e-20
C10_5 12:4 VSS:62 4.72923e-18
C10_6 12:9 VSS:62 2.30288e-18
C10_7 12:10 VSS:62 5.43471e-19
C10_8 12:10 VSS:65 5.30637e-20
C10_9 12:10 VSS:68 1.01858e-19
C10_10 12:9 VSS:69 1.9447e-18
C10_11 12:10 VSS:69 2.03492e-19
C10_12 12:4 VSS:75 4.05946e-20
C10_13 12:9 VSS:75 4.49589e-20
C10_14 12:10 VSS:75 3.39638e-18
C10_15 12:4 VSS:76 4.05946e-20
C10_16 12:9 VSS:76 4.49589e-20
C10_17 12:10 VSS:76 3.39638e-18
C10_18 M11:DRN VSS:83 3.76591e-21
C10_19 12:10 VSS:83 3.17019e-19
C10_20 12:9 VSS:84 2.17574e-20
C10_21 M12:DRN M29:DRN 2.58413e-20
C10_22 12:4 M29:DRN 5.09327e-20
C10_23 M12:DRN 11:12 1.06911e-20
C10_24 M12:DRN 11:13 2.97065e-19
C10_25 12:4 11:13 3.52008e-19
C10_26 M12:DRN 11:15 1.41222e-20
C10_27 M12:DRN 11:22 1.26047e-19
C10_28 12:4 11:22 3.99019e-19
C10_29 12:10 11:22 7.18481e-19
C10_30 M12:DRN 11:23 2.22463e-19
C10_31 12:4 11:23 6.36414e-19
C10_32 12:10 11:23 1.08238e-19
C10_33 12:4 11:24 9.67966e-20
C10_34 12:10 11:24 3.71185e-19
C10_35 M11:DRN 11:25 6.53511e-20
C10_36 12:10 11:25 5.45147e-19
Cg10_37 M12:DRN VSS 3.48269e-19
Cg10_38 12:4 VSS 8.66496e-19
Cg10_39 12:5 VSS 3.43433e-19
Cg10_40 12:9 VSS 4.50966e-19
Cg10_41 12:10 VSS 1.78284e-18
R10_1 M10:SRC 12:12 52325.6
R10_2 M10:SRC 12:9 14331.2
R10_3 M11:DRN 12:12 52325.6
R10_4 M11:DRN 12:9 14331.2
R10_5 M12:DRN 12:11 6.97918
R10_6 M12:DRN 12:4 19.8037
R10_7 12:4 12:7 6.267
R10_8 12:5 12:7 6.267
R10_9 12:6 12:7 63.5281
R10_10 12:6 12:10 3.58332
R10_11 12:6 12:8 50.1665
R10_12 12:8 12:9 63.5281
R10_13 12:8 12:13 3.58332
R10_14 12:9 12:12 10980.0

*|NET 13 5.08935e-05PF
*|I (M11:GATE M11 GATE I 2.4e-19 0.3780 0.0360)
*|I (M23:SRC M23 SRC B 0 0.5400 0.1080)
*|I (M24:DRN M24 DRN B 0 0.5100 0.1080)
*|I (M27:GATE M27 GATE I 2.4e-19 0.3780 0.1080)
*|I (M7:SRC M7 SRC B 0 0.5820 0.0360)
*|I (M8:SRC M8 SRC B 0 0.4980 0.0360)
*|I (M9:DRN M9 DRN B 0 0.4680 0.0360)
C11_1 13:23 SET:6 1.09724e-19
C11_2 13:23 SET:16 3.60342e-20
C11_3 M9:DRN SET:19 6.64083e-20
C11_4 13:14 SET:19 1.02065e-18
C11_5 13:23 SET:19 3.7956e-18
C11_6 13:14 SET:21 6.26989e-21
C11_7 13:22 SET:21 1.61156e-20
C11_8 13:23 SET:21 3.54011e-19
C11_9 M9:DRN VSS:38 6.41463e-21
C11_10 13:23 VSS:38 2.22868e-19
C11_11 13:13 VSS:42 1.05047e-18
C11_12 13:23 VSS:42 1.64738e-19
C11_13 M9:DRN VSS:62 2.33149e-20
C11_14 13:8 VSS:62 4.59992e-19
C11_15 13:9 VSS:62 7.89427e-21
C11_16 13:13 VSS:62 2.23602e-20
C11_17 13:14 VSS:62 1.90954e-18
C11_18 13:22 VSS:62 3.44005e-19
C11_19 13:28 VSS:62 6.69184e-20
C11_20 13:13 VSS:69 4.60431e-19
C11_21 13:14 VSS:69 1.89024e-18
C11_22 13:15 VSS:69 5.34944e-19
C11_23 13:23 VSS:69 6.91316e-19
C11_24 13:13 VSS:70 8.18374e-19
C11_25 13:14 VSS:70 2.23057e-20
C11_26 13:23 VSS:70 7.79235e-20
C11_27 13:22 VSS:71 9.41515e-20
C11_28 13:26 VSS:71 3.96506e-19
C11_29 13:28 VSS:71 1.96453e-19
C11_30 13:14 VSS:75 1.90012e-20
C11_31 13:22 VSS:75 1.89995e-20
C11_32 13:23 VSS:75 8.41215e-19
C11_33 13:14 VSS:76 1.90012e-20
C11_34 13:22 VSS:76 1.89995e-20
C11_35 13:23 VSS:76 8.41215e-19
C11_36 M9:DRN VSS:84 2.39008e-21
C11_37 13:23 VSS:84 1.0596e-19
C11_38 13:12 VDD:12 1.15564e-19
C11_39 13:13 VDD:12 1.11752e-18
C11_40 13:15 VDD:12 9.71694e-19
C11_41 13:12 VDD:67 2.03922e-20
C11_42 13:13 VDD:67 1.73644e-19
C11_43 13:15 VDD:67 2.77786e-20
C11_44 13:23 VDD:67 1.98107e-19
C11_45 13:26 VDD:67 4.16505e-21
C11_46 13:12 VDD:68 2.03922e-20
C11_47 13:13 VDD:68 1.73644e-19
C11_48 13:15 VDD:68 2.77786e-20
C11_49 13:23 VDD:68 1.98107e-19
C11_50 13:26 VDD:68 4.16505e-21
C11_51 13:23 VDD:75 5.95977e-20
C11_52 13:23 11:9 1.30746e-19
C11_53 13:14 11:14 8.50629e-19
C11_54 13:14 11:17 1.43871e-19
C11_55 13:23 11:17 1.66927e-18
C11_56 13:23 11:23 3.96193e-20
C11_57 13:10 11:25 9.85798e-20
C11_58 13:11 11:25 4.64075e-20
C11_59 13:14 11:25 3.34622e-21
C11_60 13:17 11:25 8.5016e-20
C11_61 13:23 11:25 7.31951e-18
C11_62 13:23 M11:DRN 1.62677e-20
C11_63 13:23 12:9 1.30534e-19
C11_64 13:8 12:10 3.74734e-20
C11_65 13:9 12:10 2.22446e-20
C11_66 13:23 12:10 2.62128e-18
Cg11_67 M24:DRN VSS 3.14909e-20
Cg11_68 13:8 VSS 1.50343e-19
Cg11_69 13:10 VSS 4.22426e-19
Cg11_70 13:12 VSS 2.66024e-19
Cg11_71 13:13 VSS 4.80266e-19
Cg11_72 13:14 VSS 4.08951e-19
Cg11_73 13:15 VSS 3.53864e-19
Cg11_74 13:17 VSS 1.12499e-19
Cg11_75 13:22 VSS 2.03026e-19
Cg11_76 13:23 VSS 2.63248e-18
Cg11_77 13:26 VSS 3.59834e-19
Cg11_78 13:28 VSS 2.60603e-19
R11_1 M11:GATE 13:9 5.05051
R11_2 M11:GATE 13:8 5.05051
R11_3 M23:SRC 13:15 45000.0
R11_4 M23:SRC 13:13 45000.0
R11_5 M23:SRC 13:29 22500.0
R11_6 M24:DRN 13:15 45000.0
R11_7 M24:DRN 13:13 45000.0
R11_8 M24:DRN 13:29 22500.0
R11_9 M27:GATE 13:11 5.05051
R11_10 M27:GATE 13:10 5.05051
R11_11 M7:SRC 13:22 34615.4
R11_12 M7:SRC 13:33 18862.1
R11_13 M8:SRC 13:32 45000.0
R11_14 M8:SRC 13:14 30000.0
R11_15 M8:SRC 13:31 30000.0
R11_16 M9:DRN 13:32 45000.0
R11_17 M9:DRN 13:14 30000.0
R11_18 M9:DRN 13:31 30000.0
R11_19 13:8 13:24 8.08081
R11_20 13:9 13:17 5.80808
R11_21 13:10 13:17 20.4545
R11_22 13:11 13:12 8.08081
R11_23 13:13 13:15 21.6544
R11_24 13:13 13:26 13.9419
R11_25 13:13 13:29 6.53368
R11_26 13:14 13:19 18.6881
R11_27 13:14 13:31 30000.0
R11_28 13:15 13:29 42000.0
R11_29 13:16 13:17 63.5281
R11_30 13:16 13:23 3.58332
R11_31 13:16 13:18 62.7081
R11_32 13:18 13:19 63.5281
R11_33 13:18 13:20 23.2916
R11_34 13:19 13:25 5.04281
R11_35 13:20 13:21 63.5281
R11_36 13:20 13:34 3.58332
R11_37 13:21 13:27 9.19571
R11_38 13:21 13:26 8.60244
R11_39 13:22 13:28 14.8318
R11_40 13:22 13:33 7333.33
R11_41 13:26 13:28 64.0767
R11_42 13:28 13:30 3.55963
R11_43 13:31 13:32 30000.0

*|NET 14 0.00010111PF
*|I (M1:GATE M1 GATE I 3.6e-19 0.9660 0.0360)
*|I (M17:GATE M17 GATE I 3.6e-19 0.9660 0.1080)
*|I (M18:DRN M18 DRN B 0 0.8460 0.1080)
*|I (M2:DRN M2 DRN B 0 0.8880 0.0360)
*|I (M22:GATE M22 GATE I 2.4e-19 0.6720 0.1080)
*|I (M23:DRN M23 DRN B 0 0.5520 0.1080)
*|I (M6:GATE M6 GATE I 2.4e-19 0.6720 0.0360)
*|I (M7:DRN M7 DRN B 0 0.5940 0.0360)
C12_1 14:34 RESET:12 1.25056e-19
C12_2 14:13 RESET:22 2.19919e-20
C12_3 14:14 RESET:22 2.90717e-20
C12_4 14:26 RESET:22 1.67016e-18
C12_5 14:34 RESET:22 5.36319e-18
C12_6 14:35 RESET:22 8.66086e-20
C12_7 14:36 RESET:22 8.52747e-19
C12_8 14:37 RESET:22 9.25114e-21
C12_9 M23:DRN RESET:23 9.98921e-21
C12_10 14:9 RESET:23 1.71389e-20
C12_11 14:24 RESET:23 2.56501e-19
C12_12 14:34 RESET:23 1.52502e-19
C12_13 14:35 RESET:23 1.1149e-20
C12_14 14:36 RESET:23 9.05192e-20
C12_15 14:16 VSS:16 1.04682e-18
C12_16 M2:DRN VSS:62 1.67881e-20
C12_17 M7:DRN VSS:62 4.02376e-19
C12_18 14:10 VSS:62 4.59992e-19
C12_19 14:11 VSS:62 7.89427e-21
C12_20 14:15 VSS:62 4.61602e-19
C12_21 14:16 VSS:62 5.91659e-19
C12_22 14:17 VSS:62 1.86805e-19
C12_23 14:20 VSS:62 6.70438e-20
C12_24 14:21 VSS:62 9.91502e-19
C12_25 14:24 VSS:62 2.30923e-20
C12_26 14:33 VSS:62 2.46722e-18
C12_27 14:37 VSS:62 7.78105e-20
C12_28 14:38 VSS:62 5.59231e-19
C12_29 14:22 VSS:71 9.09548e-19
C12_30 14:24 VSS:71 3.98316e-20
C12_31 14:26 VSS:71 1.2349e-19
C12_32 14:34 VSS:71 7.8305e-19
C12_33 14:35 VSS:71 4.08411e-20
C12_34 14:36 VSS:71 3.42121e-19
C12_35 14:33 VSS:72 7.96217e-19
C12_36 14:36 VSS:72 2.30418e-19
C12_37 14:37 VSS:72 4.0048e-19
C12_38 14:38 VSS:72 2.71589e-19
C12_39 M7:DRN VSS:75 3.25462e-20
C12_40 14:10 VSS:75 2.14113e-36
C12_41 14:15 VSS:75 1.85187e-20
C12_42 14:24 VSS:75 1.04175e-19
C12_43 14:33 VSS:75 4.99528e-20
C12_44 14:34 VSS:75 2.3245e-20
C12_45 14:36 VSS:75 1.38813e-19
C12_46 14:37 VSS:75 7.27808e-19
C12_47 14:38 VSS:75 4.88426e-19
C12_48 M7:DRN VSS:76 3.25462e-20
C12_49 14:10 VSS:76 2.14113e-36
C12_50 14:15 VSS:76 1.85187e-20
C12_51 14:24 VSS:76 1.04175e-19
C12_52 14:33 VSS:76 4.99528e-20
C12_53 14:34 VSS:76 2.3245e-20
C12_54 14:36 VSS:76 1.38813e-19
C12_55 14:37 VSS:76 7.27808e-19
C12_56 14:38 VSS:76 4.88426e-19
C12_57 14:34 VSS:85 5.88055e-21
C12_58 14:34 VSS:86 6.53511e-20
C12_59 14:36 VDD:11 9.22549e-20
C12_60 M18:DRN VDD:12 1.0328e-18
C12_61 14:9 VDD:12 1.17907e-19
C12_62 14:14 VDD:12 1.15837e-19
C12_63 14:17 VDD:12 1.86805e-19
C12_64 14:18 VDD:12 7.00521e-19
C12_65 14:19 VDD:12 3.73836e-19
C12_66 14:20 VDD:12 8.91541e-19
C12_67 14:21 VDD:12 1.65907e-18
C12_68 14:22 VDD:12 1.51177e-18
C12_69 14:23 VDD:12 1.0827e-18
C12_70 14:24 VDD:12 5.76016e-20
C12_71 14:36 VDD:12 5.37712e-20
C12_72 14:38 VDD:12 2.01141e-19
C12_73 14:43 VDD:12 2.54489e-20
C12_74 14:18 VDD:15 1.25618e-18
C12_75 14:21 VDD:65 1.52324e-20
C12_76 M18:DRN VDD:67 7.73355e-20
C12_77 M2:DRN VDD:67 1.83275e-20
C12_78 M23:DRN VDD:67 1.8133e-20
C12_79 14:9 VDD:67 2.18859e-20
C12_80 14:14 VDD:67 2.10658e-20
C12_81 14:19 VDD:67 5.86035e-20
C12_82 14:20 VDD:67 3.1224e-20
C12_83 14:21 VDD:67 2.04741e-20
C12_84 14:22 VDD:67 1.70873e-19
C12_85 14:23 VDD:67 2.86551e-20
C12_86 14:24 VDD:67 2.13643e-19
C12_87 14:26 VDD:67 5.51054e-20
C12_88 14:34 VDD:67 5.4855e-19
C12_89 14:35 VDD:67 4.84791e-20
C12_90 14:36 VDD:67 5.2069e-18
C12_91 14:37 VDD:67 2.64763e-20
C12_92 14:38 VDD:67 4.63075e-19
C12_93 M18:DRN VDD:68 7.73355e-20
C12_94 M2:DRN VDD:68 1.83275e-20
C12_95 M23:DRN VDD:68 1.8133e-20
C12_96 14:9 VDD:68 2.18859e-20
C12_97 14:14 VDD:68 2.10658e-20
C12_98 14:19 VDD:68 5.86035e-20
C12_99 14:20 VDD:68 3.1224e-20
C12_100 14:21 VDD:68 2.04741e-20
C12_101 14:22 VDD:68 1.70873e-19
C12_102 14:23 VDD:68 2.86551e-20
C12_103 14:24 VDD:68 2.13643e-19
C12_104 14:26 VDD:68 5.51054e-20
C12_105 14:34 VDD:68 5.4855e-19
C12_106 14:35 VDD:68 4.84791e-20
C12_107 14:36 VDD:68 5.2069e-18
C12_108 14:37 VDD:68 2.64763e-20
C12_109 14:38 VDD:68 4.63075e-19
C12_110 14:34 VDD:76 3.1076e-20
C12_111 14:36 VDD:76 4.55438e-20
C12_112 14:16 QN:12 1.50958e-19
C12_113 14:17 QN:12 2.26425e-19
C12_114 14:18 QN:12 1.93991e-19
C12_115 14:21 QN:12 2.90465e-19
C12_116 14:36 QN:12 4.0466e-19
C12_117 14:37 QN:12 1.41543e-18
C12_118 14:38 QN:12 6.7172e-19
C12_119 M23:DRN 13:13 1.79797e-20
C12_120 M23:DRN 13:15 2.08569e-20
C12_121 M7:DRN 13:22 3.29517e-21
C12_122 14:22 13:22 4.3348e-19
C12_123 M23:DRN 13:26 6.57856e-22
C12_124 14:22 13:26 1.58057e-18
C12_125 M7:DRN 13:28 6.05827e-21
C12_126 14:22 13:28 1.07913e-18
Cg12_127 M18:DRN VSS 1.58619e-19
Cg12_128 M7:DRN VSS 2.23598e-20
Cg12_129 14:9 VSS 5.85408e-19
Cg12_130 14:10 VSS 1.87817e-19
Cg12_131 14:11 VSS 2.22446e-20
Cg12_132 14:12 VSS 4.22426e-19
Cg12_133 14:14 VSS 2.67751e-19
Cg12_134 14:15 VSS 8.93592e-20
Cg12_135 14:17 VSS 9.8281e-19
Cg12_136 14:19 VSS 1.68609e-19
Cg12_137 14:20 VSS 6.4945e-19
Cg12_138 14:21 VSS 4.69737e-19
Cg12_139 14:22 VSS 7.25011e-19
Cg12_140 14:23 VSS 1.78054e-19
Cg12_141 14:24 VSS 4.0498e-19
Cg12_142 14:26 VSS 4.6346e-19
Cg12_143 14:27 VSS 6.35799e-20
Cg12_144 14:33 VSS 3.0914e-19
Cg12_145 14:34 VSS 1.9641e-18
Cg12_146 14:35 VSS 2.69253e-19
Cg12_147 14:36 VSS 1.66944e-18
Cg12_148 14:37 VSS 1.23179e-18
Cg12_149 14:38 VSS 7.29239e-19
Cg12_150 14:43 VSS 1.96413e-19
R12_1 M1:GATE 14:16 7.57576
R12_2 M1:GATE 14:15 7.57576
R12_3 M17:GATE 14:18 7.57576
R12_4 M17:GATE 14:17 7.57576
R12_5 M18:DRN 14:46 42613.6
R12_6 M18:DRN 14:31 7.15773
R12_7 M2:DRN 14:33 11726.7
R12_8 M22:GATE 14:13 5.05051
R12_9 M22:GATE 14:12 5.05051
R12_10 M23:DRN 14:22 12650.0
R12_11 M6:GATE 14:11 5.05051
R12_12 M6:GATE 14:10 5.05051
R12_13 M7:DRN 14:43 34615.4
R12_14 M7:DRN 14:45 18862.1
R12_15 14:9 14:20 30.0359
R12_16 14:9 14:22 30.0359
R12_17 14:9 14:39 8.58586
R12_18 14:9 14:40 19.697
R12_19 14:10 14:41 8.08081
R12_20 14:11 14:27 20.4545
R12_21 14:12 14:27 5.80808
R12_22 14:13 14:14 8.08081
R12_23 14:15 14:42 5.55556
R12_24 14:16 14:21 10.6061
R12_25 14:17 14:21 10.6061
R12_26 14:18 14:19 5.55556
R12_27 14:20 14:25 5.63608
R12_28 14:21 14:29 27.7339
R12_29 14:23 14:46 89290.9
R12_30 14:23 14:31 6.31557
R12_31 14:24 14:25 31.764
R12_32 14:24 14:26 25.436
R12_33 14:25 14:43 23.4342
R12_34 14:26 14:27 63.5281
R12_35 14:26 14:34 38.5643
R12_36 14:28 14:29 63.5281
R12_37 14:28 14:37 25.0832
R12_38 14:28 14:38 3.58332
R12_39 14:29 14:44 7.92396
R12_40 14:30 14:31 63.5281
R12_41 14:30 14:35 56.7359
R12_42 14:30 14:36 25.0832
R12_43 14:31 14:46 27600.0
R12_44 14:32 14:33 63.5281
R12_45 14:32 14:47 3.58332
R12_46 14:32 14:37 25.7999
R12_47 14:34 14:35 16.6027
R12_48 14:36 14:37 25.8596
R12_49 14:43 14:45 7333.33

*|NET 15 4.46562e-05PF
*|I (M19:GATE M19 GATE I 2.4e-19 0.7980 0.1080)
*|I (M22:SRC M22 SRC B 0 0.6660 0.1080)
*|I (M3:GATE M3 GATE I 2.4e-19 0.7980 0.0360)
*|I (M5:SRC M5 SRC B 0 0.7080 0.0360)
*|I (M6:DRN M6 DRN B 0 0.6780 0.0360)
C13_1 15:21 SET:9 1.13694e-19
C13_2 15:21 SET:18 3.60342e-20
C13_3 M6:DRN SET:20 6.55625e-20
C13_4 15:13 SET:20 1.04075e-18
C13_5 15:21 SET:20 7.49664e-18
C13_6 M6:DRN VSS:48 6.41463e-21
C13_7 15:12 VSS:48 3.11274e-19
C13_8 M6:DRN VSS:62 2.13112e-20
C13_9 15:6 VSS:62 4.59992e-19
C13_10 15:7 VSS:62 7.89427e-21
C13_11 15:12 VSS:62 1.15921e-19
C13_12 15:13 VSS:62 2.32971e-18
C13_13 15:20 VSS:62 5.53602e-21
C13_14 15:11 VSS:71 1.20206e-20
C13_15 15:12 VSS:71 2.30311e-18
C13_16 15:13 VSS:71 1.96846e-18
C13_17 15:21 VSS:71 5.24022e-19
C13_18 15:6 VSS:75 2.14113e-36
C13_19 15:13 VSS:75 3.6764e-20
C13_20 15:21 VSS:75 3.05099e-19
C13_21 15:6 VSS:76 2.14113e-36
C13_22 15:13 VSS:76 3.6764e-20
C13_23 15:21 VSS:76 3.05099e-19
C13_24 M6:DRN VSS:85 3.76591e-21
C13_25 15:12 VSS:85 6.8667e-20
C13_26 15:21 VSS:85 5.2558e-20
C13_27 15:13 VSS:86 1.96961e-20
C13_28 15:21 VSS:86 1.31767e-20
C13_29 15:10 VDD:12 1.15837e-19
C13_30 15:12 VDD:12 2.56006e-18
C13_31 15:10 VDD:67 2.10658e-20
C13_32 15:12 VDD:67 1.15566e-19
C13_33 15:21 VDD:67 6.94081e-20
C13_34 15:10 VDD:68 2.10658e-20
C13_35 15:12 VDD:68 1.15566e-19
C13_36 15:21 VDD:68 6.94081e-20
C13_37 15:21 VDD:76 5.95977e-20
C13_38 15:21 14:12 1.09943e-19
C13_39 15:12 14:26 5.58927e-20
C13_40 15:21 14:26 1.61997e-18
C13_41 15:11 14:34 4.75285e-20
C13_42 15:12 14:34 8.50486e-19
C13_43 15:13 14:34 1.78546e-19
C13_44 15:20 14:34 5.43133e-21
C13_45 15:21 14:34 7.7978e-18
C13_46 15:21 14:35 4.09678e-20
C13_47 15:9 14:36 2.19919e-20
C13_48 15:10 14:36 2.90717e-20
C13_49 15:11 14:36 1.03174e-19
C13_50 15:21 14:36 1.86266e-19
C13_51 15:21 14:37 1.58854e-22
Cg13_52 15:6 VSS 1.50343e-19
Cg13_53 15:8 VSS 4.22426e-19
Cg13_54 15:10 VSS 2.67751e-19
Cg13_55 15:11 VSS 3.27902e-19
Cg13_56 15:12 VSS 1.51324e-18
Cg13_57 15:13 VSS 4.6509e-19
Cg13_58 15:20 VSS 2.54223e-20
Cg13_59 15:21 VSS 1.5046e-18
R13_1 M19:GATE 15:9 5.05051
R13_2 M19:GATE 15:8 5.05051
R13_3 M22:SRC 15:12 37500.0
R13_4 M22:SRC 15:20 45000.0
R13_5 M22:SRC 15:26 25000.0
R13_6 M3:GATE 15:7 5.05051
R13_7 M3:GATE 15:6 5.05051
R13_8 M5:SRC 15:28 45000.0
R13_9 M5:SRC 15:13 37500.0
R13_10 M5:SRC 15:27 25000.0
R13_11 M6:DRN 15:28 45000.0
R13_12 M6:DRN 15:13 37500.0
R13_13 M6:DRN 15:27 25000.0
R13_14 15:6 15:22 8.08081
R13_15 15:7 15:11 5.80808
R13_16 15:8 15:11 20.4545
R13_17 15:9 15:10 8.08081
R13_18 15:11 15:15 27.7339
R13_19 15:12 15:17 37.6727
R13_20 15:12 15:26 8666.66
R13_21 15:13 15:19 20.4679
R13_22 15:13 15:27 39000.0
R13_23 15:14 15:15 63.5281
R13_24 15:14 15:18 50.1665
R13_25 15:14 15:29 3.58332
R13_26 15:15 15:25 7.92396
R13_27 15:16 15:17 63.5281
R13_28 15:16 15:21 3.58332
R13_29 15:16 15:18 25.0832
R13_30 15:17 15:23 4.86483
R13_31 15:18 15:19 63.5281
R13_32 15:19 15:24 5.04281
R13_33 15:20 15:26 6666.66
R13_34 15:27 15:28 30000.0

*|NET 16 2.86597e-05PF
*|I (M2:SRC M2 SRC B 0 0.8760 0.0360)
*|I (M3:SRC M3 SRC B 0 0.7920 0.0360)
*|I (M4:DRN M4 DRN B 0 0.7620 0.0360)
C14_1 16:9 SET:20 2.39329e-18
C14_2 16:9 SET:21 7.00276e-20
C14_3 M4:DRN VSS:52 6.41463e-21
C14_4 16:9 VSS:56 5.77058e-19
C14_5 M4:DRN VSS:62 2.02009e-20
C14_6 16:4 VSS:62 2.30037e-18
C14_7 16:7 VSS:62 2.30288e-18
C14_8 16:8 VSS:62 2.02063e-20
C14_9 16:9 VSS:62 3.60518e-19
C14_10 16:4 VSS:71 1.89999e-18
C14_11 16:9 VSS:71 2.93134e-19
C14_12 16:7 VSS:72 7.70398e-19
C14_13 16:9 VSS:72 1.24658e-19
C14_14 16:4 VSS:75 3.73396e-20
C14_15 16:7 VSS:75 2.52418e-20
C14_16 16:9 VSS:75 3.28557e-18
C14_17 16:4 VSS:76 3.73396e-20
C14_18 16:7 VSS:76 2.52418e-20
C14_19 16:9 VSS:76 3.28557e-18
C14_20 M4:DRN VSS:86 3.76591e-21
C14_21 16:4 VSS:87 2.17574e-20
C14_22 16:9 VSS:87 2.84299e-19
C14_23 16:7 M18:DRN 8.95705e-21
C14_24 16:7 M2:DRN 2.17574e-20
C14_25 M4:DRN 14:34 1.96053e-20
C14_26 16:9 14:34 2.349e-20
C14_27 16:7 14:36 1.13662e-20
C14_28 16:9 14:36 6.23236e-19
C14_29 16:7 14:37 7.24198e-20
C14_30 16:9 14:37 9.53936e-19
C14_31 16:9 15:6 3.74734e-20
C14_32 16:9 15:7 2.22446e-20
C14_33 16:4 15:11 1.18579e-19
C14_34 M4:DRN 15:21 5.11211e-20
C14_35 16:4 15:21 1.50919e-19
C14_36 16:9 15:21 1.12147e-18
Cg14_37 16:4 VSS 3.18176e-19
Cg14_38 16:7 VSS 3.0496e-19
Cg14_39 16:9 VSS 9.44451e-19
R14_1 M2:SRC 16:7 14331.2
R14_2 M2:SRC 16:8 52325.6
R14_3 M3:SRC 16:10 52325.6
R14_4 M3:SRC 16:4 14331.2
R14_5 M4:DRN 16:10 52325.6
R14_6 M4:DRN 16:4 14331.2
R14_7 16:4 16:5 63.5281
R14_8 16:4 16:10 10980.0
R14_9 16:5 16:9 3.58332
R14_10 16:5 16:6 48.3748
R14_11 16:6 16:7 63.5281
R14_12 16:6 16:11 3.58332
R14_13 16:7 16:8 12200.0

*|NET 17 1.28882e-05PF
*|I (M29:SRC M29 SRC B 0 0.2460 0.1080)
*|I (M30:DRN M30 DRN B 0 0.1740 0.1080)
C15_1 17:3 CK:15 1.57227e-18
C15_2 17:4 CK:15 1.44663e-20
C15_3 17:3 CK:24 2.75472e-19
C15_4 17:4 CK:24 2.25405e-19
C15_5 17:3 CK:25 1.58097e-19
C15_6 17:4 CK:25 9.84159e-22
C15_7 17:3 VSS:65 9.62208e-19
C15_8 17:4 VSS:65 8.0263e-19
C15_9 17:3 VDD:12 3.74442e-18
C15_10 17:3 VDD:14 2.82443e-20
C15_11 17:3 VDD:23 2.13821e-20
C15_12 17:3 VDD:67 4.26702e-19
C15_13 17:3 VDD:68 4.26702e-19
Cg15_14 17:3 VSS 1.16563e-18
Cg15_15 17:4 VSS 3.73519e-19
R15_1 M29:SRC 17:4 7500.0
R15_2 M30:DRN 17:3 7500.0
R15_3 17:3 17:4 9.75247

*|NET 18 9.51717e-06PF
*|I (M27:SRC M27 SRC B 0 0.3720 0.1080)
*|I (M28:DRN M28 DRN B 0 0.3000 0.1155)
C16_1 18:4 VSS:34 8.67191e-21
C16_2 M28:DRN VSS:62 2.62895e-21
C16_3 18:3 VSS:62 5.51419e-21
C16_4 18:4 VSS:62 3.29333e-20
C16_5 M27:SRC VSS:69 3.27701e-19
C16_6 18:3 VSS:69 4.05083e-19
C16_7 18:4 VSS:83 1.2156e-20
C16_8 M27:SRC VDD:12 1.00629e-18
C16_9 M28:DRN VDD:12 1.00629e-18
C16_10 18:3 VDD:12 3.24772e-18
C16_11 M27:SRC VDD:67 2.79122e-20
C16_12 M28:DRN VDD:67 2.79122e-20
C16_13 18:3 VDD:67 2.10785e-19
C16_14 M27:SRC VDD:68 2.79122e-20
C16_15 M28:DRN VDD:68 2.79122e-20
C16_16 18:3 VDD:68 2.10785e-19
C16_17 M28:DRN 11:13 1.06911e-20
C16_18 M28:DRN 11:16 1.41222e-20
C16_19 M27:SRC 11:24 4.60302e-20
C16_20 M28:DRN 11:24 9.49983e-20
C16_21 18:3 11:24 7.84183e-19
C16_22 18:4 11:24 3.63631e-20
C16_23 18:3 11:25 3.32986e-20
C16_24 18:4 11:25 4.58972e-20
Cg16_25 M27:SRC VSS 2.21661e-19
Cg16_26 M28:DRN VSS 4.92728e-19
Cg16_27 18:3 VSS 5.48435e-19
Cg16_28 18:4 VSS 5.43642e-21
R16_1 M27:SRC 18:4 67500.0
R16_2 M27:SRC 18:5 45608.1
R16_3 M27:SRC 18:3 46.0474
R16_4 M28:DRN 18:3 88.1801
R16_5 18:3 18:5 16200.0
R16_6 18:4 18:5 15000.0

*|NET 2 0.000188697PF
*|I (M13:GATE M13 GATE I 3.6e-19 0.2100 0.0360)
*|I (M15:GATE M15 GATE I 3.6e-19 0.0840 0.0360)
*|I (M16:SRC M16 SRC B 0 0.0360 0.0360)
*|I (M2:GATE M2 GATE I 2.4e-19 0.8820 0.0360)
*|I (M23:GATE M23 GATE I 2.4e-19 0.5460 0.1080)
*|I (M28:GATE M28 GATE I 1.8e-19 0.2940 0.1155)
*|I (M31:GATE M31 GATE I 3.6e-19 0.0840 0.1080)
*|I (M32:SRC M32 SRC B 0 0.0360 0.1080)
C17_1 2:66 CK:8 1.42824e-21
C17_2 2:67 CK:8 1.42824e-21
C17_3 2:66 CK:12 8.56944e-21
C17_4 2:67 CK:12 8.56944e-21
C17_5 2:27 CK:14 7.70097e-19
C17_6 2:61 CK:14 4.85297e-20
C17_7 2:25 CK:23 1.94178e-19
C17_8 2:26 CK:23 2.24709e-19
C17_9 2:32 CK:23 1.002e-19
C17_10 2:33 CK:23 1.002e-19
C17_11 2:60 CK:23 6.93738e-18
C17_12 2:61 CK:23 2.44011e-18
C17_13 2:66 CK:23 5.89304e-19
C17_14 2:67 CK:23 5.89304e-19
C17_15 2:28 CK:24 1.29193e-19
C17_16 2:62 CK:24 6.04557e-19
C17_17 2:63 CK:24 2.76073e-20
C17_18 2:66 CK:24 2.7061e-19
C17_19 2:67 CK:24 2.7061e-19
C17_20 2:12 CK:25 1.71389e-20
C17_21 2:16 CK:25 1.71389e-20
C17_22 2:60 CK:25 3.82162e-19
C17_23 2:61 CK:25 2.82329e-19
C17_24 2:62 CK:25 9.08581e-20
C17_25 2:66 CK:25 9.68157e-19
C17_26 2:67 CK:25 9.68157e-19
C17_27 2:66 SET:19 4.58929e-19
C17_28 2:67 SET:19 4.58929e-19
C17_29 2:66 SET:20 1.27927e-18
C17_30 2:67 SET:20 1.27927e-18
C17_31 2:64 SET:21 2.76375e-19
C17_32 2:66 SET:21 4.54292e-18
C17_33 2:67 SET:21 4.54292e-18
C17_34 2:64 RESET:21 5.84637e-19
C17_35 2:66 RESET:21 2.225e-20
C17_36 2:67 RESET:21 2.225e-20
C17_37 2:64 RESET:22 2.80825e-19
C17_38 2:20 RESET:23 1.03547e-21
C17_39 2:21 RESET:23 3.92766e-22
C17_40 2:30 RESET:23 2.37131e-21
C17_41 2:64 RESET:23 1.12539e-18
C17_42 2:66 RESET:23 2.65754e-19
C17_43 2:67 RESET:23 2.65754e-19
C17_44 2:61 VSS:14 4.03332e-20
C17_45 2:62 VSS:15 2.37386e-20
C17_46 2:27 VSS:20 2.35434e-19
C17_47 2:61 VSS:20 3.71231e-19
C17_48 2:66 VSS:20 1.48207e-21
C17_49 2:67 VSS:20 1.48207e-21
C17_50 2:62 VSS:24 4.32189e-20
C17_51 M16:SRC VSS:62 3.49455e-21
C17_52 M32:SRC VSS:62 6.41999e-21
C17_53 2:9 VSS:62 4.60557e-19
C17_54 2:10 VSS:62 7.89427e-21
C17_55 2:14 VSS:62 4.61602e-19
C17_56 2:15 VSS:62 7.89427e-21
C17_57 2:17 VSS:62 4.69803e-19
C17_58 2:20 VSS:62 1.85022e-21
C17_59 2:22 VSS:62 4.61686e-19
C17_60 2:23 VSS:62 7.89427e-21
C17_61 2:24 VSS:62 2.26792e-21
C17_62 2:25 VSS:62 1.93442e-18
C17_63 2:26 VSS:62 6.25953e-20
C17_64 2:29 VSS:62 3.31601e-20
C17_65 2:32 VSS:62 5.48721e-20
C17_66 2:60 VSS:62 7.49119e-20
C17_67 2:61 VSS:62 3.6477e-20
C17_68 2:62 VSS:62 3.72356e-20
C17_69 2:64 VSS:62 3.88385e-20
C17_70 2:25 VSS:65 1.07009e-18
C17_71 2:26 VSS:65 1.07009e-18
C17_72 2:28 VSS:65 5.09526e-21
C17_73 2:32 VSS:65 8.03181e-19
C17_74 2:33 VSS:65 8.03181e-19
C17_75 2:60 VSS:65 7.27555e-19
C17_76 2:61 VSS:65 2.57177e-19
C17_77 2:62 VSS:65 2.35148e-19
C17_78 2:63 VSS:65 1.796e-19
C17_79 2:66 VSS:65 6.66358e-20
C17_80 2:67 VSS:65 6.66358e-20
C17_81 2:25 VSS:66 2.13821e-20
C17_82 2:32 VSS:66 2.82443e-20
C17_83 2:61 VSS:66 6.15644e-21
C17_84 2:29 VSS:68 4.66947e-19
C17_85 2:63 VSS:68 1.51638e-19
C17_86 2:66 VSS:68 1.03337e-20
C17_87 2:67 VSS:68 1.03337e-20
C17_88 2:29 VSS:69 7.05068e-21
C17_89 2:64 VSS:69 1.80669e-19
C17_90 2:66 VSS:69 1.37782e-20
C17_91 2:67 VSS:69 1.37782e-20
C17_92 2:30 VSS:71 1.44288e-19
C17_93 2:64 VSS:71 2.21556e-19
C17_94 2:66 VSS:71 4.92284e-20
C17_95 2:67 VSS:71 4.92284e-20
C17_96 2:22 VSS:72 5.12057e-21
C17_97 2:24 VSS:72 2.71823e-19
C17_98 2:31 VSS:72 7.72846e-20
C17_99 2:65 VSS:72 2.89777e-19
C17_100 2:66 VSS:72 4.42871e-21
C17_101 2:67 VSS:72 4.42871e-21
C17_102 2:9 VSS:75 9.87412e-21
C17_103 2:14 VSS:75 9.62609e-21
C17_104 2:22 VSS:75 2.01483e-20
C17_105 2:25 VSS:75 5.68167e-20
C17_106 2:60 VSS:75 5.80804e-19
C17_107 2:61 VSS:75 2.90996e-19
C17_108 2:62 VSS:75 2.76916e-19
C17_109 2:63 VSS:75 5.74835e-20
C17_110 2:64 VSS:75 2.73606e-19
C17_111 2:65 VSS:75 7.61845e-20
C17_112 2:66 VSS:75 2.98443e-18
C17_113 2:9 VSS:76 9.87412e-21
C17_114 2:14 VSS:76 9.62609e-21
C17_115 2:22 VSS:76 2.01483e-20
C17_116 2:25 VSS:76 5.68167e-20
C17_117 2:60 VSS:76 5.80804e-19
C17_118 2:61 VSS:76 2.90996e-19
C17_119 2:62 VSS:76 2.76916e-19
C17_120 2:63 VSS:76 5.74835e-20
C17_121 2:64 VSS:76 2.73606e-19
C17_122 2:65 VSS:76 7.61845e-20
C17_123 2:67 VSS:76 2.98443e-18
C17_124 2:13 VDD:12 1.15061e-19
C17_125 2:16 VDD:12 1.20735e-19
C17_126 2:19 VDD:12 1.15217e-19
C17_127 2:21 VDD:12 1.15886e-19
C17_128 2:24 VDD:12 1.57237e-19
C17_129 2:26 VDD:12 1.46007e-18
C17_130 2:28 VDD:12 1.78996e-20
C17_131 2:30 VDD:12 1.15087e-18
C17_132 2:31 VDD:12 2.02348e-19
C17_133 2:27 VDD:19 5.4878e-19
C17_134 2:61 VDD:19 1.70023e-20
C17_135 2:26 VDD:62 2.13821e-20
C17_136 2:27 VDD:62 5.0701e-21
C17_137 2:33 VDD:62 2.82443e-20
C17_138 2:13 VDD:67 1.77269e-20
C17_139 2:14 VDD:67 1.97291e-21
C17_140 2:16 VDD:67 1.9189e-20
C17_141 2:19 VDD:67 2.08871e-20
C17_142 2:21 VDD:67 2.47939e-20
C17_143 2:24 VDD:67 4.1493e-20
C17_144 2:26 VDD:67 1.31341e-19
C17_145 2:27 VDD:67 9.61511e-21
C17_146 2:28 VDD:67 1.65327e-22
C17_147 2:30 VDD:67 3.90765e-20
C17_148 2:60 VDD:67 5.9233e-19
C17_149 2:61 VDD:67 1.722e-19
C17_150 2:62 VDD:67 1.69607e-19
C17_151 2:63 VDD:67 4.48021e-20
C17_152 2:64 VDD:67 7.2314e-19
C17_153 2:65 VDD:67 4.84721e-20
C17_154 2:66 VDD:67 2.63213e-19
C17_155 2:13 VDD:68 1.77269e-20
C17_156 2:14 VDD:68 1.97291e-21
C17_157 2:16 VDD:68 1.9189e-20
C17_158 2:19 VDD:68 2.08871e-20
C17_159 2:21 VDD:68 2.47939e-20
C17_160 2:24 VDD:68 4.1493e-20
C17_161 2:26 VDD:68 1.31341e-19
C17_162 2:27 VDD:68 9.61511e-21
C17_163 2:28 VDD:68 1.65327e-22
C17_164 2:30 VDD:68 3.90765e-20
C17_165 2:60 VDD:68 5.9233e-19
C17_166 2:61 VDD:68 1.722e-19
C17_167 2:62 VDD:68 1.69607e-19
C17_168 2:63 VDD:68 4.48021e-20
C17_169 2:64 VDD:68 7.2314e-19
C17_170 2:65 VDD:68 4.84721e-20
C17_171 2:67 VDD:68 2.63213e-19
C17_172 2:66 D:6 8.56944e-21
C17_173 2:67 D:6 8.56944e-21
C17_174 2:61 D:11 1.03217e-19
C17_175 2:62 D:11 1.21906e-18
C17_176 2:66 D:11 6.2215e-19
C17_177 2:67 D:11 6.2215e-19
C17_178 2:29 M29:DRN 7.49483e-20
C17_179 2:66 11:12 4.94023e-21
C17_180 2:67 11:12 4.94023e-21
C17_181 2:63 11:17 3.24993e-20
C17_182 2:64 11:17 2.47214e-19
C17_183 2:66 11:17 8.77877e-20
C17_184 2:67 11:17 8.77877e-20
C17_185 2:66 11:22 6.6169e-19
C17_186 2:67 11:22 6.6169e-19
C17_187 2:62 11:23 2.63275e-19
C17_188 2:63 11:23 1.28881e-18
C17_189 2:64 11:23 4.32202e-21
C17_190 2:66 11:23 6.06348e-19
C17_191 2:67 11:23 6.06348e-19
C17_192 2:17 11:24 8.39359e-20
C17_193 2:18 11:24 5.82772e-20
C17_194 2:19 11:24 2.07767e-20
C17_195 2:29 11:24 1.15133e-19
C17_196 2:63 11:24 7.77543e-19
C17_197 2:66 11:24 1.23235e-19
C17_198 2:67 11:24 1.23235e-19
C17_199 2:29 11:25 8.50062e-21
C17_200 2:63 11:25 2.30133e-19
C17_201 2:64 11:25 2.52948e-19
C17_202 2:66 11:25 5.2901e-19
C17_203 2:67 11:25 5.2901e-19
C17_204 2:18 12:4 5.80708e-20
C17_205 2:19 12:4 5.518e-21
C17_206 2:29 12:4 4.90518e-19
C17_207 2:63 12:4 1.79903e-19
C17_208 2:29 12:5 4.31601e-19
C17_209 2:63 12:5 9.15385e-20
C17_210 2:29 12:10 1.58538e-20
C17_211 2:63 12:10 1.82454e-18
C17_212 2:66 12:10 1.03731e-18
C17_213 2:67 12:10 1.03731e-18
C17_214 2:64 13:13 1.38494e-19
C17_215 2:66 13:13 2.37131e-21
C17_216 2:67 13:13 2.37131e-21
C17_217 2:66 13:14 9.0294e-22
C17_218 2:67 13:14 9.0294e-22
C17_219 2:64 13:15 1.00033e-19
C17_220 2:64 13:22 8.11547e-20
C17_221 2:66 13:22 1.73663e-20
C17_222 2:67 13:22 1.73663e-20
C17_223 2:29 13:23 2.93704e-21
C17_224 2:63 13:23 4.85531e-19
C17_225 2:64 13:23 1.44412e-18
C17_226 2:66 13:23 1.94945e-18
C17_227 2:67 13:23 1.94945e-18
C17_228 2:20 13:26 4.67642e-19
C17_229 2:64 13:26 3.45961e-19
C17_230 2:64 13:28 9.6354e-20
C17_231 2:66 13:28 9.48524e-21
C17_232 2:67 13:28 9.48524e-21
C17_233 2:31 M18:DRN 2.82967e-19
C17_234 2:65 M18:DRN 1.54418e-20
C17_235 2:64 M23:DRN 9.40409e-20
C17_236 2:66 14:20 2.37131e-20
C17_237 2:67 14:20 2.37131e-20
C17_238 2:24 14:21 1.29987e-20
C17_239 2:31 14:21 2.43179e-19
C17_240 2:30 14:22 6.6474e-19
C17_241 2:64 14:22 1.5403e-19
C17_242 2:64 14:24 5.48952e-20
C17_243 2:66 14:24 1.26099e-19
C17_244 2:67 14:24 1.26099e-19
C17_245 2:65 14:26 4.04018e-21
C17_246 2:66 14:26 8.69379e-20
C17_247 2:67 14:26 8.69379e-20
C17_248 2:22 14:33 2.82338e-20
C17_249 2:64 14:34 5.74841e-20
C17_250 2:65 14:34 8.82724e-21
C17_251 2:66 14:34 5.53823e-19
C17_252 2:67 14:34 5.53823e-19
C17_253 2:64 14:35 2.21368e-20
C17_254 2:24 14:36 1.50713e-19
C17_255 2:31 14:36 1.05437e-19
C17_256 2:65 14:36 7.72154e-19
C17_257 2:66 14:36 3.58502e-19
C17_258 2:67 14:36 3.58502e-19
C17_259 2:22 14:37 3.36127e-20
C17_260 2:23 14:37 8.84911e-20
C17_261 2:24 14:37 3.24859e-19
C17_262 2:65 14:37 1.13599e-18
C17_263 2:66 14:37 1.58093e-19
C17_264 2:67 14:37 1.58093e-19
C17_265 2:24 14:38 7.32183e-20
C17_266 2:31 14:38 2.70352e-19
C17_267 2:65 14:38 6.4372e-19
C17_268 2:66 14:38 1.0416e-20
C17_269 2:67 14:38 1.0416e-20
C17_270 2:66 14:43 7.55603e-22
C17_271 2:67 14:43 7.55603e-22
C17_272 2:66 15:8 8.56944e-21
C17_273 2:67 15:8 8.56944e-21
C17_274 2:66 15:11 1.89705e-20
C17_275 2:67 15:11 1.89705e-20
C17_276 2:66 15:12 9.0294e-22
C17_277 2:67 15:12 9.0294e-22
C17_278 2:66 15:13 9.0294e-22
C17_279 2:67 15:13 9.0294e-22
C17_280 2:64 15:21 4.59657e-20
C17_281 2:65 15:21 1.31915e-19
C17_282 2:66 15:21 1.73983e-18
C17_283 2:67 15:21 1.73983e-18
C17_284 2:23 16:7 8.25614e-19
C17_285 2:31 16:7 6.02986e-20
C17_286 2:65 16:7 1.14369e-19
C17_287 2:23 16:9 2.96055e-20
C17_288 2:65 16:9 1.53764e-18
C17_289 2:66 16:9 1.05953e-18
C17_290 2:67 16:9 1.05953e-18
C17_291 2:14 17:3 1.70634e-21
C17_292 2:28 17:3 2.6527e-18
C17_293 2:62 17:3 3.56162e-20
Cg17_294 2:9 VSS 1.11907e-19
Cg17_295 2:11 VSS 3.4119e-19
Cg17_296 2:13 VSS 2.26163e-19
Cg17_297 2:14 VSS 1.08686e-19
Cg17_298 2:16 VSS 8.16771e-19
Cg17_299 2:17 VSS 7.9611e-19
Cg17_300 2:19 VSS 2.27134e-19
Cg17_301 2:20 VSS 1.62471e-19
Cg17_302 2:21 VSS 2.68147e-19
Cg17_303 2:22 VSS 1.98637e-19
Cg17_304 2:24 VSS 1.67413e-18
Cg17_305 2:25 VSS 3.79183e-19
Cg17_306 2:26 VSS 3.43042e-19
Cg17_307 2:27 VSS 1.10516e-19
Cg17_308 2:28 VSS 1.86362e-19
Cg17_309 2:29 VSS 5.80265e-19
Cg17_310 2:30 VSS 1.99897e-19
Cg17_311 2:31 VSS 3.09771e-19
Cg17_312 2:32 VSS 2.6046e-19
Cg17_313 2:33 VSS 2.6046e-19
Cg17_314 2:60 VSS 2.98109e-18
Cg17_315 2:61 VSS 5.43698e-19
Cg17_316 2:62 VSS 7.09629e-19
Cg17_317 2:63 VSS 5.90475e-19
Cg17_318 2:64 VSS 1.11196e-18
Cg17_319 2:65 VSS 6.62786e-19
Cg17_320 2:66 VSS 5.24186e-18
Cg17_321 2:67 VSS 5.24186e-18
R17_1 M13:GATE 2:15 7.57576
R17_2 M13:GATE 2:14 7.57576
R17_3 M15:GATE 2:10 7.57576
R17_4 M15:GATE 2:9 7.57576
R17_5 M16:SRC 2:32 30000.0
R17_6 M16:SRC 2:25 30000.0
R17_7 M16:SRC 2:57 15000.0
R17_8 M2:GATE 2:23 5.05051
R17_9 M2:GATE 2:22 5.05051
R17_10 M23:GATE 2:53 3.66162
R17_11 M23:GATE 2:20 5.05051
R17_12 M28:GATE 2:18 3.78788
R17_13 M28:GATE 2:17 3.78788
R17_14 M31:GATE 2:12 7.57576
R17_15 M31:GATE 2:11 7.57576
R17_16 M32:SRC 2:33 30000.0
R17_17 M32:SRC 2:26 30000.0
R17_18 M32:SRC 2:59 15000.0
R17_19 2:9 2:68 5.55556
R17_20 2:10 2:27 10.6061
R17_21 2:11 2:27 10.6061
R17_22 2:12 2:13 5.55556
R17_23 2:14 2:69 5.55556
R17_24 2:15 2:16 10.6061
R17_25 2:16 2:70 31.3131
R17_26 2:16 2:49 27.7339
R17_27 2:17 2:29 18.1818
R17_28 2:18 2:19 5.55556
R17_29 2:20 2:72 10.101
R17_30 2:21 2:53 9.44444
R17_31 2:22 2:73 8.08081
R17_32 2:23 2:24 13.1313
R17_33 2:24 2:55 21.1306
R17_34 2:24 2:74 31.3131
R17_35 2:25 2:57 9.78801
R17_36 2:26 2:59 9.78801
R17_37 2:27 2:47 9.24462
R17_38 2:28 2:49 7.92396
R17_39 2:29 2:71 31.3131
R17_40 2:29 2:51 27.7339
R17_41 2:30 2:53 15.8479
R17_42 2:31 2:55 7.92396
R17_43 2:32 2:57 9.78801
R17_44 2:33 2:59 9.78801
R17_45 2:34 2:35 63.5281
R17_46 2:34 2:66 3.72918
R17_47 2:34 2:36 34.8057
R17_48 2:35 2:56 12.8402
R17_49 2:35 2:58 30.1596
R17_50 2:36 2:37 63.5281
R17_51 2:36 2:38 69.6114
R17_52 2:37 2:61 5.9722
R17_53 2:37 2:46 8.65969
R17_54 2:38 2:39 63.5281
R17_55 2:38 2:40 78.3128
R17_56 2:39 2:62 5.9722
R17_57 2:39 2:48 8.65969
R17_58 2:40 2:41 63.5281
R17_59 2:40 2:42 147.303
R17_60 2:41 2:63 5.9722
R17_61 2:41 2:50 8.65969
R17_62 2:42 2:43 63.5281
R17_63 2:42 2:44 195.16
R17_64 2:43 2:64 5.9722
R17_65 2:43 2:52 34.5193
R17_66 2:44 2:45 63.5281
R17_67 2:44 2:67 3.72918
R17_68 2:45 2:65 5.9722
R17_69 2:45 2:54 8.65969
R17_70 2:46 2:47 63.5281
R17_71 2:46 2:78 3.58332
R17_72 2:47 2:75 7.92396
R17_73 2:48 2:49 63.5281
R17_74 2:48 2:79 3.58332
R17_75 2:50 2:51 63.5281
R17_76 2:50 2:80 3.58332
R17_77 2:51 2:76 7.92396
R17_78 2:52 2:53 63.5281
R17_79 2:52 2:81 3.58332
R17_80 2:54 2:55 63.5281
R17_81 2:54 2:82 3.58332
R17_82 2:56 2:57 63.5281
R17_83 2:56 2:60 5.9722
R17_84 2:58 2:59 63.5281
R17_85 2:58 2:77 5.9722

*|NET 21 1.75081e-07PF
*|I (M26:SRC M26 SRC B 0 0.4140 0.1080)
*|I (M27:DRN M27 DRN B 0 0.3840 0.1080)
C18_1 M27:DRN RESET:21 2.02806e-20
C18_2 M27:DRN VDD:67 1.91747e-20
C18_3 M27:DRN VDD:68 1.91747e-20
C18_4 M27:DRN 11:25 3.1076e-20
C18_5 M27:DRN 12:9 1.7175e-20
C18_6 M27:DRN 13:23 5.95977e-20
C18_7 M27:DRN M27:SRC 4.89568e-21
C18_8 M27:DRN 18:3 3.70623e-21
R18_1 M26:SRC M27:DRN 22500.0

*|NET 22 8.98274e-07PF
*|I (M24:SRC M24 SRC B 0 0.4980 0.1080)
*|I (M25:DRN M25 DRN B 0 0.4680 0.1080)
C19_1 M25:DRN RESET:21 4.64089e-20
C19_2 M25:DRN VDD:10 6.41463e-21
C19_3 M25:DRN VDD:67 2.10732e-20
C19_4 M25:DRN VDD:68 2.10732e-20
C19_5 M25:DRN VDD:75 3.76591e-21
C19_6 M25:DRN 11:14 7.48373e-19
C19_7 M25:DRN 11:17 3.86554e-21
C19_8 M25:DRN 11:25 1.54109e-21
C19_9 M25:DRN 13:14 4.24322e-20
C19_10 M25:DRN 13:23 3.32638e-21
R19_1 M24:SRC M25:DRN 22500.0

*|NET 23 3.00016e-07PF
*|I (M21:SRC M21 SRC B 0 0.7080 0.1080)
*|I (M22:DRN M22 DRN B 0 0.6780 0.1080)
C20_1 M22:DRN RESET:22 4.26387e-20
C20_2 M22:DRN VDD:67 1.42102e-20
C20_3 M22:DRN VDD:68 1.42102e-20
C20_4 M22:DRN 14:34 9.63183e-21
C20_5 M22:DRN 15:12 1.75784e-20
C20_6 M22:DRN 15:13 1.8049e-19
C20_7 M22:DRN 15:21 2.12565e-20
R20_1 M21:SRC M22:DRN 22500.0

*|NET 24 4.04432e-07PF
*|I (M19:SRC M19 SRC B 0 0.7920 0.1080)
*|I (M20:DRN M20 DRN B 0 0.7620 0.1080)
C21_1 M20:DRN VDD:11 6.41463e-21
C21_2 M20:DRN VDD:67 8.86074e-21
C21_3 M20:DRN VDD:68 8.86074e-21
C21_4 M20:DRN VDD:76 3.76591e-21
C21_5 M20:DRN 14:35 4.83598e-20
C21_6 M20:DRN 14:36 6.95844e-20
C21_7 M20:DRN 15:11 2.08654e-19
C21_8 M20:DRN 15:21 4.4999e-20
Cg21_9 M20:DRN VSS 4.93215e-21
R21_1 M19:SRC M20:DRN 22500.0

*|NET 25 2.70058e-07PF
*|I (M18:SRC M18 SRC B 0 0.8340 0.1080)
*|I (M19:DRN M19 DRN B 0 0.8040 0.1080)
C22_1 M19:DRN VSS:56 3.46876e-21
C22_2 M19:DRN VSS:87 5.45466e-21
C22_3 M19:DRN VDD:67 1.08315e-20
C22_4 M19:DRN VDD:68 1.08315e-20
C22_5 M19:DRN 14:36 4.86164e-20
R22_1 M18:SRC M19:DRN 22500.0

*|NET 26 6.63472e-07PF
*|I (M13:SRC M13 SRC B 0 0.2040 0.0360)
*|I (M14:DRN M14 DRN B 0 0.1740 0.0360)
C23_1 M14:DRN VSS:15 2.82443e-20
C23_2 M14:DRN VSS:24 2.13821e-20
C23_3 M14:DRN VSS:62 4.77014e-19
C23_4 M14:DRN VSS:75 4.54164e-20
C23_5 M14:DRN VSS:76 4.54164e-20
C23_6 M14:DRN 2:62 4.59985e-20
R23_1 M13:SRC M14:DRN 15000.0

*|NET 4 0.000145794PF
*|I (M15:DRN M15 DRN B 0 0.0900 0.0360)
*|I (M18:GATE M18 GATE I 2.4e-19 0.8400 0.1080)
*|I (M31:DRN M31 DRN B 0 0.0900 0.1080)
*|I (M7:GATE M7 GATE I 2.28e-19 0.5880 0.0360)
C24_1 4:31 CK:12 8.56944e-21
C24_2 4:32 CK:12 8.56944e-21
C24_3 4:27 CK:23 1.67725e-18
C24_4 4:31 CK:23 1.03934e-19
C24_5 4:32 CK:23 1.03934e-19
C24_6 4:27 CK:24 3.29101e-20
C24_7 4:31 CK:24 5.56223e-19
C24_8 4:32 CK:24 5.56223e-19
C24_9 M31:DRN CK:25 3.93663e-21
C24_10 4:27 CK:25 9.68851e-19
C24_11 4:31 CK:25 4.62194e-18
C24_12 4:32 CK:25 4.62194e-18
C24_13 4:20 SET:19 7.84139e-20
C24_14 4:28 SET:19 3.07795e-19
C24_15 4:20 SET:20 1.56519e-19
C24_16 4:28 SET:20 7.67616e-19
C24_17 4:31 SET:20 1.8717e-20
C24_18 4:32 SET:20 1.8717e-20
C24_19 4:20 SET:21 5.6142e-19
C24_20 4:28 SET:21 1.00974e-18
C24_21 4:31 SET:21 2.66041e-19
C24_22 4:32 SET:21 2.66041e-19
C24_23 4:31 RESET:21 7.7067e-19
C24_24 4:32 RESET:21 7.7067e-19
C24_25 4:31 RESET:22 7.1115e-19
C24_26 4:32 RESET:22 7.1115e-19
C24_27 4:28 RESET:23 2.77467e-19
C24_28 4:31 RESET:23 4.52662e-18
C24_29 4:32 RESET:23 4.52662e-18
C24_30 M15:DRN VSS:14 2.82443e-20
C24_31 4:27 VSS:14 7.83415e-20
C24_32 M15:DRN VSS:20 2.13821e-20
C24_33 4:27 VSS:20 8.80947e-20
C24_34 4:11 VSS:56 2.47409e-20
C24_35 M15:DRN VSS:62 1.02342e-19
C24_36 4:6 VSS:62 4.74644e-19
C24_37 4:9 VSS:62 2.32548e-18
C24_38 4:11 VSS:62 7.64204e-20
C24_39 4:20 VSS:62 1.2079e-19
C24_40 4:21 VSS:62 8.20148e-19
C24_41 4:27 VSS:62 6.64965e-20
C24_42 4:28 VSS:62 2.71918e-20
C24_43 4:27 VSS:65 5.82245e-19
C24_44 4:31 VSS:65 6.48707e-20
C24_45 4:32 VSS:65 6.59591e-20
C24_46 4:31 VSS:68 1.02311e-20
C24_47 4:32 VSS:68 1.02311e-20
C24_48 4:31 VSS:69 2.31277e-20
C24_49 4:32 VSS:69 2.31277e-20
C24_50 4:11 VSS:71 8.00373e-21
C24_51 4:20 VSS:71 1.81303e-20
C24_52 4:28 VSS:71 2.40761e-19
C24_53 4:29 VSS:71 1.79828e-19
C24_54 4:30 VSS:71 3.38638e-20
C24_55 4:31 VSS:71 2.21436e-20
C24_56 4:32 VSS:71 2.21436e-20
C24_57 4:9 VSS:75 1.47015e-20
C24_58 4:20 VSS:75 8.46158e-19
C24_59 4:27 VSS:75 6.07959e-19
C24_60 4:28 VSS:75 2.37752e-19
C24_61 4:29 VSS:75 7.83186e-21
C24_62 4:30 VSS:75 5.06014e-20
C24_63 4:31 VSS:75 1.18687e-19
C24_64 4:9 VSS:76 1.47015e-20
C24_65 4:20 VSS:76 8.46158e-19
C24_66 4:27 VSS:76 6.07959e-19
C24_67 4:28 VSS:76 2.37752e-19
C24_68 4:29 VSS:76 7.83186e-21
C24_69 4:30 VSS:76 5.06014e-20
C24_70 4:32 VSS:76 1.18687e-19
C24_71 4:11 VSS:87 2.99379e-20
C24_72 4:30 VSS:87 1.30379e-20
C24_73 4:8 VDD:12 1.15837e-19
C24_74 4:10 VDD:12 1.06187e-18
C24_75 M31:DRN VDD:13 2.82443e-20
C24_76 4:27 VDD:13 1.09314e-19
C24_77 M31:DRN VDD:19 2.13821e-20
C24_78 4:27 VDD:19 1.55702e-19
C24_79 4:8 VDD:67 2.10658e-20
C24_80 4:10 VDD:67 6.82354e-20
C24_81 4:20 VDD:67 1.60536e-21
C24_82 4:27 VDD:67 5.69963e-19
C24_83 4:28 VDD:67 3.40152e-19
C24_84 4:29 VDD:67 6.94992e-20
C24_85 4:31 VDD:67 1.73481e-18
C24_86 4:8 VDD:68 2.10658e-20
C24_87 4:10 VDD:68 6.82354e-20
C24_88 4:20 VDD:68 1.60536e-21
C24_89 4:27 VDD:68 5.69963e-19
C24_90 4:28 VDD:68 3.40152e-19
C24_91 4:29 VDD:68 6.94992e-20
C24_92 4:32 VDD:68 1.73481e-18
C24_93 4:31 D:6 8.56944e-21
C24_94 4:32 D:6 8.56944e-21
C24_95 4:27 D:11 3.67586e-18
C24_96 4:31 D:11 5.62412e-19
C24_97 4:32 D:11 5.62412e-19
C24_98 4:31 11:9 8.56944e-21
C24_99 4:32 11:9 8.56944e-21
C24_100 4:31 11:14 1.89705e-20
C24_101 4:32 11:14 1.89705e-20
C24_102 4:28 11:17 3.27975e-20
C24_103 4:31 11:17 3.90084e-19
C24_104 4:32 11:17 3.90084e-19
C24_105 4:27 11:22 1.10812e-20
C24_106 4:31 11:22 8.96822e-20
C24_107 4:32 11:22 8.96822e-20
C24_108 4:27 11:23 2.0236e-21
C24_109 4:28 11:23 9.46886e-21
C24_110 4:31 11:23 5.97866e-19
C24_111 4:32 11:23 5.97866e-19
C24_112 4:31 11:24 8.05296e-19
C24_113 4:32 11:24 8.05296e-19
C24_114 4:28 11:25 1.96884e-20
C24_115 4:31 11:25 2.11207e-18
C24_116 4:32 11:25 2.11207e-18
C24_117 4:31 13:13 2.37131e-20
C24_118 4:32 13:13 2.37131e-20
C24_119 4:28 13:22 1.05627e-19
C24_120 4:28 13:23 7.88621e-20
C24_121 4:31 13:23 5.80685e-19
C24_122 4:32 13:23 5.80685e-19
C24_123 4:28 13:26 7.17635e-20
C24_124 4:31 13:26 6.26597e-21
C24_125 4:32 13:26 6.26597e-21
C24_126 4:28 13:28 1.66309e-19
C24_127 4:31 13:28 1.36103e-20
C24_128 4:32 13:28 1.36103e-20
C24_129 4:28 M7:DRN 6.20213e-21
C24_130 4:5 14:9 5.62172e-19
C24_131 4:21 14:9 6.28461e-20
C24_132 4:28 14:9 2.33821e-20
C24_133 4:31 14:9 7.1412e-22
C24_134 4:32 14:9 7.1412e-22
C24_135 4:5 14:22 6.83055e-21
C24_136 4:21 14:22 2.3113e-21
C24_137 4:28 14:22 2.24902e-19
C24_138 4:31 14:22 4.15562e-21
C24_139 4:32 14:22 4.15562e-21
C24_140 4:28 14:24 8.58257e-19
C24_141 4:29 14:24 2.77534e-21
C24_142 4:31 14:24 2.32406e-19
C24_143 4:32 14:24 2.32406e-19
C24_144 4:28 14:26 3.67141e-20
C24_145 4:29 14:26 4.8145e-20
C24_146 4:31 14:26 3.78336e-19
C24_147 4:32 14:26 3.78336e-19
C24_148 4:28 14:34 1.01743e-18
C24_149 4:29 14:34 5.00131e-19
C24_150 4:31 14:34 1.93874e-18
C24_151 4:32 14:34 1.93874e-18
C24_152 4:29 14:35 1.99165e-19
C24_153 4:31 14:35 2.67397e-19
C24_154 4:32 14:35 2.67397e-19
C24_155 4:7 14:36 2.19919e-20
C24_156 4:8 14:36 2.90717e-20
C24_157 4:11 14:36 4.49353e-20
C24_158 4:29 14:36 1.94899e-18
C24_159 4:30 14:36 1.70203e-20
C24_160 4:31 14:36 4.35178e-19
C24_161 4:32 14:36 4.35178e-19
C24_162 4:28 14:37 1.80472e-20
C24_163 4:29 14:37 3.58384e-19
C24_164 4:30 14:37 2.40628e-20
C24_165 4:31 14:37 7.77255e-20
C24_166 4:32 14:37 7.77255e-20
C24_167 4:29 14:38 3.68917e-20
C24_168 4:31 14:38 5.28464e-21
C24_169 4:32 14:38 5.28464e-21
C24_170 4:31 15:8 8.56944e-21
C24_171 4:32 15:8 8.56944e-21
C24_172 4:28 15:21 3.99443e-19
C24_173 4:29 15:21 1.45931e-19
C24_174 4:30 15:21 1.78834e-19
C24_175 4:31 15:21 4.56049e-19
C24_176 4:32 15:21 4.56049e-19
C24_177 4:6 16:9 9.10322e-20
C24_178 4:29 16:9 9.00174e-20
C24_179 4:30 16:9 7.78235e-19
C24_180 4:31 16:9 3.21931e-20
C24_181 4:32 16:9 3.21931e-20
C24_182 4:31 2:16 8.56944e-21
C24_183 4:32 2:16 8.56944e-21
C24_184 4:31 2:17 8.56944e-21
C24_185 4:32 2:17 8.56944e-21
C24_186 4:31 2:20 7.1412e-22
C24_187 4:32 2:20 7.1412e-22
C24_188 4:31 2:28 2.32715e-20
C24_189 4:32 2:28 2.32715e-20
C24_190 4:27 2:60 2.01259e-19
C24_191 4:31 2:60 9.90345e-21
C24_192 4:32 2:60 9.90345e-21
C24_193 4:27 2:61 2.44634e-18
C24_194 4:31 2:61 6.20508e-20
C24_195 4:32 2:61 6.20508e-20
C24_196 4:27 2:62 9.90114e-20
C24_197 4:31 2:62 2.54082e-19
C24_198 4:32 2:62 2.54082e-19
C24_199 4:28 2:63 1.41282e-21
C24_200 4:31 2:63 2.66557e-19
C24_201 4:32 2:63 2.66557e-19
C24_202 4:28 2:64 3.21443e-18
C24_203 4:29 2:64 4.32202e-21
C24_204 4:31 2:64 5.55701e-19
C24_205 4:32 2:64 5.55701e-19
C24_206 4:28 2:65 9.21424e-21
C24_207 4:29 2:65 5.22961e-19
C24_208 4:30 2:65 2.8773e-19
C24_209 4:31 2:65 4.8282e-20
C24_210 4:32 2:65 4.8282e-20
C24_211 4:5 2:66 7.1412e-22
C24_212 4:6 2:66 8.18263e-21
C24_213 4:27 2:66 5.6966e-19
C24_214 4:28 2:66 6.21125e-19
C24_215 4:29 2:66 6.19139e-20
C24_216 4:30 2:66 3.0021e-19
C24_217 4:31 2:66 2.20675e-17
C24_218 4:5 2:67 7.1412e-22
C24_219 4:6 2:67 8.18263e-21
C24_220 4:27 2:67 5.6966e-19
C24_221 4:28 2:67 6.21125e-19
C24_222 4:29 2:67 6.19139e-20
C24_223 4:30 2:67 3.0021e-19
C24_224 4:32 2:67 2.20675e-17
C24_225 4:11 M19:DRN 1.86989e-19
C24_226 4:29 M19:DRN 3.86554e-21
Cg24_227 M31:DRN VSS 5.43919e-21
Cg24_228 4:5 VSS 2.75686e-19
Cg24_229 4:6 VSS 7.14874e-19
Cg24_230 4:8 VSS 2.67751e-19
Cg24_231 4:9 VSS 2.64052e-19
Cg24_232 4:10 VSS 2.37768e-19
Cg24_233 4:11 VSS 2.14113e-19
Cg24_234 4:12 VSS 1.78742e-19
Cg24_235 4:13 VSS 1.78742e-19
Cg24_236 4:20 VSS 1.63759e-19
Cg24_237 4:21 VSS 2.43713e-19
Cg24_238 4:27 VSS 1.38076e-18
Cg24_239 4:28 VSS 1.33908e-18
Cg24_240 4:29 VSS 6.40339e-19
Cg24_241 4:30 VSS 3.02608e-19
Cg24_242 4:31 VSS 3.58809e-18
Cg24_243 4:32 VSS 3.58809e-18
R24_1 M15:DRN 4:12 30000.0
R24_2 M15:DRN 4:9 30000.0
R24_3 M15:DRN 4:24 15000.0
R24_4 M18:GATE 4:7 5.05051
R24_5 M18:GATE 4:6 5.05051
R24_6 M31:DRN 4:13 30000.0
R24_7 M31:DRN 4:10 30000.0
R24_8 M31:DRN 4:26 15000.0
R24_9 M7:GATE 4:5 15.1515
R24_10 M7:GATE 4:21 3.63636
R24_11 4:6 4:11 13.1313
R24_12 4:7 4:8 8.08081
R24_13 4:9 4:24 9.78801
R24_14 4:10 4:26 9.78801
R24_15 4:11 4:22 21.1306
R24_16 4:11 4:34 31.3131
R24_17 4:12 4:24 9.78801
R24_18 4:13 4:26 9.78801
R24_19 4:14 4:15 63.5281
R24_20 4:14 4:31 3.72918
R24_21 4:14 4:16 296.47
R24_22 4:15 4:23 30.1596
R24_23 4:15 4:25 12.8402
R24_24 4:16 4:17 63.5281
R24_25 4:16 4:18 147.303
R24_26 4:17 4:28 32.0707
R24_27 4:17 4:37 5.9722
R24_28 4:18 4:19 63.5281
R24_29 4:18 4:32 3.72918
R24_30 4:19 4:29 6.27081
R24_31 4:19 4:38 5.9722
R24_32 4:20 4:21 63.5281
R24_33 4:20 4:28 2.34136
R24_34 4:21 4:33 7.95455
R24_35 4:22 4:35 7.92396
R24_36 4:22 4:30 63.5281
R24_37 4:23 4:24 63.5281
R24_38 4:23 4:27 5.9722
R24_39 4:25 4:26 63.5281
R24_40 4:25 4:36 5.9722
R24_41 4:29 4:30 1.95113

*|NET _generated_27 2.86359e-06PF
C25_1 _generated_27:1 VSS:65 6.61794e-19
C25_2 _generated_27:1 VSS:75 1.12789e-20
C25_3 _generated_27:1 VSS:76 1.12789e-20
C25_4 _generated_27:1 M32:SRC 5.43919e-21
C25_5 _generated_27:1 2:25 3.44976e-19
C25_6 _generated_27:1 2:60 2.80823e-19
Cg25_7 _generated_27:1 VSS 9.68959e-19
R25_1 _generated_27:1 _generated_27:2 28.2828

*|NET _generated_28 3.14476e-06PF
C26_1 _generated_28:1 VSS:62 1.47021e-19
C26_2 _generated_28:1 VSS:65 6.55949e-19
C26_3 _generated_28:1 VDD:12 1.18927e-19
C26_4 _generated_28:1 VDD:67 2.50114e-20
C26_5 _generated_28:1 VDD:68 2.50114e-20
C26_6 _generated_28:1 2:26 3.45379e-19
C26_7 _generated_28:1 2:60 2.96365e-19
C26_8 _generated_28:1 _generated_27:1 5.79044e-19
Cg26_9 _generated_28:1 VSS 9.5205e-19
R26_1 _generated_28:1 _generated_28:2 28.2828

*|NET _generated_29 3.00629e-06PF
C27_1 _generated_29:1 VSS:24 3.51758e-19
C27_2 _generated_29:1 VSS:65 6.07959e-19
C27_3 _generated_29:1 VSS:75 3.51971e-20
C27_4 _generated_29:1 VSS:76 3.51971e-20
C27_5 _generated_29:1 D:11 1.88138e-19
Cg27_6 _generated_29:1 VSS 1.2024e-18
R27_1 _generated_29:1 _generated_29:2 28.2828

*|NET _generated_30 3.19898e-06PF
C28_1 _generated_30:1 VSS:62 9.47793e-20
C28_2 _generated_30:1 VSS:65 5.15218e-19
C28_3 _generated_30:1 VDD:12 1.18927e-19
C28_4 _generated_30:1 VDD:23 3.79482e-19
C28_5 _generated_30:1 VDD:67 4.60412e-20
C28_6 _generated_30:1 VDD:68 4.60412e-20
C28_7 _generated_30:1 D:11 1.91408e-19
C28_8 _generated_30:1 _generated_29:1 5.85636e-19
Cg28_9 _generated_30:1 VSS 1.22144e-18
R28_1 _generated_30:1 _generated_30:2 28.2828

*|NET _generated_31 3.3652e-06PF
C29_1 _generated_31:1 VSS:34 2.29425e-19
C29_2 _generated_31:1 VSS:69 6.65873e-19
C29_3 _generated_31:1 VSS:75 1.55681e-21
C29_4 _generated_31:1 VSS:76 1.55681e-21
C29_5 _generated_31:1 VSS:83 3.29507e-19
C29_6 _generated_31:1 12:10 2.38451e-19
Cg29_7 _generated_31:1 VSS 1.32469e-18
R29_1 _generated_31:1 _generated_31:2 28.2828

*|NET _generated_32 4.06253e-06PF
C30_1 _generated_32:1 VSS:62 1.35664e-19
C30_2 _generated_32:1 VSS:69 1.15507e-18
C30_3 _generated_32:1 VDD:12 1.18193e-19
C30_4 _generated_32:1 VDD:67 2.31394e-20
C30_5 _generated_32:1 VDD:68 2.31394e-20
C30_6 _generated_32:1 11:24 1.77604e-19
C30_7 _generated_32:1 11:25 2.10757e-19
C30_8 _generated_32:1 18:4 5.86523e-19
C30_9 _generated_32:1 _generated_31:1 5.74141e-19
Cg30_10 _generated_32:1 VSS 1.0583e-18
R30_1 _generated_32:1 _generated_32:2 28.2828

*|NET _generated_33 1.32824e-06PF
C31_1 _generated_33:1 VSS:62 4.66718e-19
C31_2 _generated_33:1 VSS:75 2.48404e-20
C31_3 _generated_33:1 VSS:76 2.48404e-20
C31_4 _generated_33:1 13:26 1.11763e-19
C31_5 _generated_33:1 2:20 1.89626e-20
C31_6 _generated_33:1 2:64 5.79969e-20
C31_7 _generated_33:1 2:66 7.1412e-22
C31_8 _generated_33:1 2:67 7.1412e-22
Cg31_9 _generated_33:1 VSS 6.21694e-19
R31_1 _generated_33:1 _generated_33:2 28.2828

*|NET _generated_34 3.84309e-06PF
C32_1 _generated_34:1 SET:20 2.26584e-19
C32_2 _generated_34:1 VSS:71 1.144e-18
C32_3 _generated_34:1 VSS:75 2.07359e-21
C32_4 _generated_34:1 VSS:76 2.07359e-21
C32_5 _generated_34:1 VSS:85 5.93165e-19
C32_6 _generated_34:1 15:20 5.43551e-21
C32_7 _generated_34:1 15:21 1.83781e-19
Cg32_8 _generated_34:1 VSS 1.11344e-18
R32_1 _generated_34:1 _generated_34:2 28.2828

*|NET _generated_35 4.13377e-06PF
C33_1 _generated_35:1 RESET:22 1.94232e-19
C33_2 _generated_35:1 RESET:23 7.18801e-22
C33_3 _generated_35:1 VSS:62 8.22057e-20
C33_4 _generated_35:1 VSS:71 1.13081e-18
C33_5 _generated_35:1 VDD:12 1.18193e-19
C33_6 _generated_35:1 VDD:67 2.31394e-20
C33_7 _generated_35:1 VDD:68 2.31394e-20
C33_8 _generated_35:1 14:22 1.01875e-20
C33_9 _generated_35:1 14:26 1.16415e-20
C33_10 _generated_35:1 14:34 2.10719e-19
C33_11 _generated_35:1 15:20 5.90972e-19
C33_12 _generated_35:1 _generated_34:1 5.72546e-19
Cg33_13 _generated_35:1 VSS 1.16527e-18
R33_1 _generated_35:1 _generated_35:2 28.2828

*|NET _generated_36 4.80924e-06PF
C34_1 _generated_36:1 VSS:62 8.19721e-19
C34_2 _generated_36:1 VSS:72 5.35441e-19
C34_3 _generated_36:1 VSS:75 4.30198e-20
C34_4 _generated_36:1 VSS:76 4.30198e-20
C34_5 _generated_36:1 14:16 3.95054e-20
C34_6 _generated_36:1 14:17 9.05603e-20
C34_7 _generated_36:1 14:33 6.21044e-19
C34_8 _generated_36:1 14:37 7.33514e-20
C34_9 _generated_36:1 14:38 1.28879e-19
C34_10 _generated_36:1 2:22 1.48543e-19
C34_11 _generated_36:1 2:24 4.56652e-19
Cg34_12 _generated_36:1 VSS 1.23388e-18
R34_1 _generated_36:1 _generated_36:2 28.2828

*|NET _generated_37 5.76748e-06PF
C35_1 _generated_37:1 VSS:72 3.79868e-19
C35_2 _generated_37:1 VDD:12 5.04056e-19
C35_3 _generated_37:1 VDD:67 5.66167e-20
C35_4 _generated_37:1 VDD:68 5.66167e-20
C35_5 _generated_37:1 14:17 1.82326e-19
C35_6 _generated_37:1 14:18 4.74065e-20
C35_7 _generated_37:1 14:19 3.10326e-20
C35_8 _generated_37:1 14:36 2.19364e-20
C35_9 _generated_37:1 14:37 4.22436e-20
C35_10 _generated_37:1 14:38 3.77838e-20
C35_11 _generated_37:1 2:24 2.56198e-18
C35_12 _generated_37:1 _generated_36:1 5.75623e-19
Cg35_13 _generated_37:1 VSS 1.26999e-18
R35_1 _generated_37:1 _generated_37:2 28.2828

*|NET _generated_38 5.07024e-06PF
C36_1 _generated_38:1 VSS:62 4.61748e-19
C36_2 _generated_38:1 VSS:72 2.98844e-20
C36_3 _generated_38:1 VSS:75 4.08139e-20
C36_4 _generated_38:1 VSS:76 4.08139e-20
C36_5 _generated_38:1 QN:4 1.90957e-19
C36_6 _generated_38:1 QN:12 5.63516e-20
C36_7 _generated_38:1 14:17 2.39886e-19
Cg36_8 _generated_38:1 VSS 3.40563e-18
R36_1 _generated_38:1 _generated_38:2 28.2828

*|NET _generated_39 4.96832e-06PF
C37_1 _generated_39:1 VDD:12 1.1978e-19
C37_2 _generated_39:1 VDD:67 9.59123e-20
C37_3 _generated_39:1 VDD:68 9.59123e-20
C37_4 _generated_39:1 QN:5 3.81915e-19
C37_5 _generated_39:1 QN:12 6.07984e-20
C37_6 _generated_39:1 14:17 2.39886e-19
C37_7 _generated_39:1 14:19 4.75026e-20
C37_8 _generated_39:1 _generated_38:1 6.0415e-19
Cg37_9 _generated_39:1 VSS 3.32246e-18
R37_1 _generated_39:1 _generated_39:2 28.2828

*
* Instance Section
*
MM1 M1:DRN M1:GATE M1:SRC VSS NMOS_LVT l=0.012u w=0.03u NF=1
MM10 M10:DRN M10:GATE M10:SRC VSS NMOS_LVT_WGAA_20nm l=0.012u w=0.02u NF=1
MM11 M11:DRN M11:GATE M11:SRC VSS NMOS_LVT_WGAA_20nm l=0.012u w=0.02u NF=1
MM12 M12:DRN M12:GATE M12:SRC VSS NMOS_LVT_WGAA_15nm l=0.012u w=0.015u NF=1
MM13 M13:DRN M13:GATE M13:SRC VSS NMOS_LVT l=0.012u w=0.03u NF=1
MM14 M14:DRN M14:GATE M14:SRC VSS NMOS_LVT l=0.012u w=0.03u NF=1
MM15 M15:DRN M15:GATE M15:SRC VSS NMOS_LVT l=0.012u w=0.03u NF=1
MM16 M16:DRN M16:GATE M16:SRC VSS NMOS_LVT l=0.012u w=0.03u NF=1
MM17 M17:DRN M17:GATE M17:SRC VDD PMOS_LVT l=0.012u w=0.03u NF=1
MM18 M18:DRN M18:GATE M18:SRC VDD PMOS_LVT_WGAA_20nm l=0.012u w=0.02u NF=1
MM19 M19:DRN M19:GATE M19:SRC VDD PMOS_LVT_WGAA_20nm l=0.012u w=0.02u NF=1
MM2 M2:DRN M2:GATE M2:SRC VSS NMOS_LVT_WGAA_20nm l=0.012u w=0.02u NF=1
MM20 M20:DRN M20:GATE M20:SRC VDD PMOS_LVT_WGAA_20nm l=0.012u w=0.02u NF=1
MM21 M21:DRN M21:GATE M21:SRC VDD PMOS_LVT_WGAA_20nm l=0.012u w=0.02u NF=1
MM22 M22:DRN M22:GATE M22:SRC VDD PMOS_LVT_WGAA_20nm l=0.012u w=0.02u NF=1
MM23 M23:DRN M23:GATE M23:SRC VDD PMOS_LVT_WGAA_20nm l=0.012u w=0.02u NF=1
MM24 M24:DRN M24:GATE M24:SRC VDD PMOS_LVT_WGAA_20nm l=0.012u w=0.02u NF=1
MM25 M25:DRN M25:GATE M25:SRC VDD PMOS_LVT_WGAA_20nm l=0.012u w=0.02u NF=1
MM26 M26:DRN M26:GATE M26:SRC VDD PMOS_LVT_WGAA_20nm l=0.012u w=0.02u NF=1
MM27 M27:DRN M27:GATE M27:SRC VDD PMOS_LVT_WGAA_20nm l=0.012u w=0.02u NF=1
MM28 M28:DRN M28:GATE M28:SRC VDD PMOS_LVT_WGAA_15nm l=0.012u w=0.015u NF=1
MM29 M29:DRN M29:GATE M29:SRC VDD PMOS_LVT l=0.012u w=0.03u NF=1
MM3 M3:DRN M3:GATE M3:SRC VSS NMOS_LVT_WGAA_20nm l=0.012u w=0.02u NF=1
MM30 M30:DRN M30:GATE M30:SRC VDD PMOS_LVT l=0.012u w=0.03u NF=1
MM31 M31:DRN M31:GATE M31:SRC VDD PMOS_LVT l=0.012u w=0.03u NF=1
MM32 M32:DRN M32:GATE M32:SRC VDD PMOS_LVT l=0.012u w=0.03u NF=1
MM4 M4:DRN M4:GATE M4:SRC VSS NMOS_LVT_WGAA_20nm l=0.012u w=0.02u NF=1
MM5 M5:DRN M5:GATE M5:SRC VSS NMOS_LVT_WGAA_20nm l=0.012u w=0.02u NF=1
MM6 M6:DRN M6:GATE M6:SRC VSS NMOS_LVT_WGAA_20nm l=0.012u w=0.02u NF=1
MM7 M7:DRN M7:GATE M7:SRC VSS NMOS_LVT_WGAA_19nm l=0.012u w=0.019u NF=1
MM8 M8:DRN M8:GATE M8:SRC VSS NMOS_LVT_WGAA_20nm l=0.012u w=0.02u NF=1
MM9 M9:DRN M9:GATE M9:SRC VSS NMOS_LVT_WGAA_20nm l=0.012u w=0.02u NF=1

.ENDS
