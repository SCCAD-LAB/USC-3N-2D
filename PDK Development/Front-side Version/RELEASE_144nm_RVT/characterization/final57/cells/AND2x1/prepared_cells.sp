*
*|DSPF 1.3
*|DESIGN AND2x1
*|DATE "Tue Nov  3 20:50:56 2026"
*|VENDOR "Synopsys"
*|PROGRAM "StarRC"
*|VERSION "X-2025.06-SP1"
*|DIVIDER /
*|DELIMITER :
**FORMAT SPF
*

** COMMENTS

** OPERATING_TEMPERATURE 25
** GLOBAL_TEMPERATURE 25
**
** TCAD_GRD_FILE /cedar/cedar_coe/ece-limsk/yhuang861/GRO/.planning/experiments_migrated_20261022/usc144_github_release_20261103/sources/github_FSPR.nxtgrd
**   TCAD_TIME_STAMP Tue Mar 31 05:07:55 2026
**   TCADGRD_VERSION 89

.SUBCKT AND2x1 VSS VDD Y A B

*|GROUND_NET VSS

*|NET VSS 8.60045e-05PF
*|P (VSS B 0 0.1050 0.0000)
*|I (M1:SRC M1 SRC B 0 0.1620 0.0360)
*|I (M3:SRC M3 SRC B 0 0.0360 0.0360)
Cg1_1 VSS:4 VSS 2.52098e-19
Cg1_2 VSS:5 VSS 2.52098e-19
Cg1_3 VSS:11 VSS 2.53884e-18
Cg1_4 VSS:14 VSS 3.09039e-17
Cg1_5 VSS:17 VSS 4.8713e-18
Cg1_6 VSS:19 VSS 6.99712e-18
Cg1_7 VSS:20 VSS 5.2628e-19
R1_1 VSS VSS:7 25.0832
R1_2 VSS VSS:10 25.0832
R1_3 VSS VSS:9 63.5281
R1_4 M1:SRC VSS:16 30000.0
R1_5 M1:SRC VSS:5 30000.0
R1_6 M1:SRC VSS:25 15000.0
R1_7 M3:SRC VSS:15 30000.0
R1_8 M3:SRC VSS:4 30000.0
R1_9 M3:SRC VSS:23 15000.0
R1_10 VSS:4 VSS:23 7.8411
R1_11 VSS:4 VSS:20 12.4587
R1_12 VSS:5 VSS:25 7.8411
R1_13 VSS:5 VSS:11 12.4587
R1_14 VSS:6 VSS:19 17.9166
R1_15 VSS:6 VSS:7 25.0832
R1_16 VSS:6 VSS:20 31.764
R1_17 VSS:7 VSS:8 63.5281
R1_18 VSS:8 VSS:20 50.1851
R1_19 VSS:8 VSS:9 55.4677
R1_20 VSS:9 VSS:11 50.1851
R1_21 VSS:10 VSS:11 31.764
R1_22 VSS:10 VSS:12 25.0832
R1_23 VSS:11 VSS:13 50.1851
R1_24 VSS:12 VSS:13 63.5281
R1_25 VSS:12 VSS:27 17.9166
R1_26 VSS:13 VSS:22 39.6198
R1_27 VSS:14 VSS:17 7778.54
R1_28 VSS:15 VSS:23 7.8411
R1_29 VSS:15 VSS:24 1.77981
R1_30 VSS:16 VSS:25 7.8411
R1_31 VSS:16 VSS:26 1.77981
R1_32 VSS:17 VSS:18 2881.1
R1_33 VSS:20 VSS:21 34.3372
R1_34 VSS:20 VSS:14 0.01

*|NET VDD 4.70329e-05PF
*|P (VDD B 0 0.1050 0.1440)
*|I (M4:SRC M4 SRC B 0 0.1620 0.1080)
*|I (M5:DRN M5 DRN B 0 0.0900 0.1080)
*|I (M6:SRC M6 SRC B 0 0.0360 0.1080)
C2_1 VDD VSS:11 9.71927e-20
C2_2 VDD:12 VSS:11 1.61563e-19
C2_3 VDD:15 VSS:11 6.70874e-21
C2_4 VDD:18 VSS:11 3.96321e-21
C2_5 VDD:20 VSS:11 6.38861e-20
C2_6 VDD VSS:14 1.24156e-18
C2_7 VDD:5 VSS:14 8.02586e-19
C2_8 VDD:12 VSS:14 3.57267e-19
C2_9 VDD:20 VSS:14 1.49966e-18
C2_10 VDD VSS:19 1.14951e-18
C2_11 VDD:12 VSS:19 2.76282e-20
C2_12 VDD VSS:20 8.78916e-22
C2_13 VDD:15 VSS:20 3.86285e-21
C2_14 VDD:20 VSS:20 1.20446e-19
Cg2_15 VDD VSS 6.6616e-18
Cg2_16 VDD:5 VSS 2.52098e-19
Cg2_17 VDD:6 VSS 1.78742e-19
Cg2_18 VDD:7 VSS 1.90317e-19
Cg2_19 VDD:12 VSS 1.12073e-17
Cg2_20 VDD:15 VSS 5.43919e-21
Cg2_21 VDD:17 VSS 5.43766e-21
Cg2_22 VDD:18 VSS 5.43766e-21
Cg2_23 VDD:19 VSS 6.02006e-19
Cg2_24 VDD:20 VSS 7.91159e-19
R2_1 VDD VDD:9 25.0832
R2_2 VDD VDD:11 25.0832
R2_3 VDD VDD:16 38682.6
R2_4 VDD VDD:19 31.764
R2_5 M4:SRC VDD:18 30000.0
R2_6 M4:SRC VDD:7 30000.0
R2_7 M4:SRC VDD:27 15000.0
R2_8 M5:DRN VDD:17 30000.0
R2_9 M5:DRN VDD:6 30000.0
R2_10 M5:DRN VDD:25 15000.0
R2_11 M6:SRC VDD:15 30000.0
R2_12 M6:SRC VDD:5 30000.0
R2_13 M6:SRC VDD:23 15000.0
R2_14 VDD:5 VDD:23 7.8411
R2_15 VDD:5 VDD:24 1.77981
R2_16 VDD:6 VDD:25 7.8411
R2_17 VDD:6 VDD:26 1.77981
R2_18 VDD:7 VDD:27 7.8411
R2_19 VDD:7 VDD:28 1.77981
R2_20 VDD:8 VDD:29 17.9166
R2_21 VDD:8 VDD:9 25.0832
R2_22 VDD:8 VDD:20 31.764
R2_23 VDD:9 VDD:10 63.5281
R2_24 VDD:10 VDD:20 50.1851
R2_25 VDD:10 VDD:19 50.1851
R2_26 VDD:11 VDD:12 31.764
R2_27 VDD:11 VDD:13 25.0832
R2_28 VDD:12 VDD:14 50.1851
R2_29 VDD:12 VDD:18 12.4587
R2_30 VDD:12 VDD:19 44.9024
R2_31 VDD:13 VDD:14 63.5281
R2_32 VDD:13 VDD:30 17.9166
R2_33 VDD:14 VDD:22 39.6198
R2_34 VDD:15 VDD:23 7.8411
R2_35 VDD:15 VDD:20 12.4587
R2_36 VDD:17 VDD:25 7.8411
R2_37 VDD:17 VDD:19 12.4587
R2_38 VDD:18 VDD:27 7.8411
R2_39 VDD:20 VDD:21 34.3372

*|NET Y 1.84493e-05PF
*|P (Y B 0 0.1890 0.0720)
*|I (M1:DRN M1 DRN B 0 0.1740 0.0360)
*|I (M4:DRN M4 DRN B 0 0.1740 0.1080)
C3_1 M1:DRN VSS:5 2.82443e-20
C3_2 Y:12 VSS:5 8.37831e-20
C3_3 M1:DRN VSS:11 1.20262e-19
C3_4 Y:4 VSS:11 2.51883e-18
C3_5 Y:12 VSS:11 1.8597e-19
C3_6 Y:12 VSS:14 6.48876e-19
C3_7 Y:12 VSS:17 7.77805e-20
C3_8 Y:12 VSS:18 2.22064e-19
C3_9 Y:4 VSS:19 6.47028e-20
C3_10 Y:12 VSS:19 1.55194e-18
C3_11 Y:5 VDD 2.90191e-19
C3_12 Y:12 VDD 1.43894e-18
C3_13 M4:DRN VDD:7 3.78986e-20
C3_14 Y:12 VDD:7 1.77132e-19
C3_15 M4:DRN VDD:12 6.2592e-20
C3_16 Y:5 VDD:12 1.05946e-18
C3_17 Y:12 VDD:12 3.05127e-19
Cg3_18 Y:4 VSS 3.15906e-19
Cg3_19 Y:5 VSS 2.8933e-19
Cg3_20 Y:6 VSS 1.78742e-19
Cg3_21 Y:7 VSS 1.78742e-19
Cg3_22 Y:12 VSS 3.15003e-18
R3_1 Y Y:10 21.4999
R3_2 Y Y:8 21.4999
R3_3 M1:DRN Y:6 30000.0
R3_4 M1:DRN Y:4 30000.0
R3_5 M1:DRN Y:9 15000.0
R3_6 M4:DRN Y:7 30000.0
R3_7 M4:DRN Y:5 30000.0
R3_8 M4:DRN Y:11 15000.0
R3_9 Y:4 Y:9 9.78801
R3_10 Y:5 Y:11 9.78801
R3_11 Y:6 Y:9 9.78801
R3_12 Y:7 Y:11 9.78801
R3_13 Y:8 Y:9 63.5281
R3_14 Y:8 Y:12 7.8833
R3_15 Y:10 Y:11 63.5281
R3_16 Y:10 Y:13 7.94303

*|NET A 1.85236e-05PF
*|P (A B 0 0.0210 0.0720)
*|I (M3:GATE M3 GATE I 3.6e-19 0.0420 0.0360)
*|I (M6:GATE M6 GATE I 3.6e-19 0.0420 0.1080)
C4_1 A:10 VSS:4 2.31333e-19
C4_2 A:4 VSS:11 4.61602e-19
C4_3 A:5 VSS:11 7.89427e-21
C4_4 A:10 VSS:11 9.63817e-20
C4_5 A:10 VSS:14 9.47122e-19
C4_6 A:10 VSS:15 4.74872e-20
C4_7 A:4 VSS:19 2.75992e-20
C4_8 A:10 VSS:19 1.48672e-18
C4_9 A:8 VSS:20 9.16124e-19
C4_10 A:10 VSS:20 6.15563e-19
C4_11 A:4 VDD 4.02543e-21
C4_12 A:7 VDD 4.85422e-20
C4_13 A:8 VDD 2.83023e-20
C4_14 A:10 VDD 1.49455e-18
C4_15 A:10 VDD:5 1.1494e-19
C4_16 A:7 VDD:12 1.15802e-19
C4_17 A:8 VDD:15 1.48933e-20
C4_18 A:10 VDD:15 1.18559e-19
C4_19 A:8 VDD:20 1.58128e-18
C4_20 A:10 VDD:20 4.73109e-19
Cg4_21 A:4 VSS 1.09486e-19
Cg4_22 A:6 VSS 3.4119e-19
Cg4_23 A:7 VSS 2.31874e-19
Cg4_24 A:8 VSS 1.99342e-19
Cg4_25 A:10 VSS 3.70439e-18
R4_1 A A:10 29.3832
R4_2 A A:13 29.4429
R4_3 A A:9 63.5281
R4_4 M3:GATE A:5 7.57576
R4_5 M3:GATE A:4 7.57576
R4_6 M6:GATE A:7 13.1313
R4_7 M6:GATE A:6 7.57576
R4_8 A:4 A:11 5.55556
R4_9 A:5 A:8 10.6061
R4_10 A:6 A:8 10.6061
R4_11 A:8 A:9 27.7339
R4_12 A:9 A:12 7.92396

*|NET B 1.82617e-05PF
*|P (B B 0 0.1050 0.0720)
*|I (M2:GATE M2 GATE I 3.6e-19 0.0840 0.0360)
*|I (M5:GATE M5 GATE I 3.6e-19 0.0840 0.1080)
C5_1 B:4 VSS:11 4.74367e-19
C5_2 B:5 VSS:11 7.89427e-21
C5_3 B:8 VSS:14 4.73412e-19
C5_4 B:10 VSS:14 4.96553e-19
C5_5 B:4 VSS:19 4.39135e-20
C5_6 B:10 VSS:19 1.59353e-19
C5_7 B:7 VDD 1.39605e-19
C5_8 B:10 VDD 1.53945e-18
C5_9 B:10 VDD:6 2.24872e-19
C5_10 B:7 VDD:12 1.16249e-19
C5_11 B:8 VDD:17 1.75802e-20
C5_12 B:10 VDD:17 3.96939e-20
C5_13 B:8 VDD:19 1.56217e-18
C5_14 B:10 VDD:19 4.44267e-19
C5_15 B:10 Y:12 1.04431e-18
Cg5_16 B:4 VSS 2.19217e-19
Cg5_17 B:6 VSS 3.4119e-19
Cg5_18 B:7 VSS 1.57023e-19
Cg5_19 B:8 VSS 1.97637e-19
Cg5_20 B:10 VSS 1.86024e-18
R5_1 B B:10 12.8402
R5_2 B B:13 29.4429
R5_3 B B:9 63.5281
R5_4 M2:GATE B:5 7.57576
R5_5 M2:GATE B:4 7.57576
R5_6 M5:GATE B:7 13.1313
R5_7 M5:GATE B:6 7.57576
R5_8 B:4 B:11 5.55556
R5_9 B:5 B:8 10.6061
R5_10 B:6 B:8 10.6061
R5_11 B:8 B:9 27.7339
R5_12 B:9 B:12 7.92396

*|NET 10 7.93503e-07PF
*|I (M2:SRC M2 SRC B 0 0.0780 0.0360)
*|I (M3:DRN M3 DRN B 0 0.0480 0.0360)
C7_1 M3:DRN VSS:4 2.82443e-20
C7_2 M3:DRN VSS:11 4.69247e-19
C7_3 M3:DRN VSS:19 1.11356e-19
C7_4 M3:DRN VSS:20 2.13821e-20
R7_1 M2:SRC M3:DRN 15000.0

*|NET 4 5.04998e-05PF
*|I (M1:GATE M1 GATE I 3.6e-19 0.1680 0.0360)
*|I (M2:DRN M2 DRN B 0 0.0900 0.0360)
*|I (M4:GATE M4 GATE I 3.6e-19 0.1680 0.1080)
*|I (M5:SRC M5 SRC B 0 0.0780 0.1080)
*|I (M6:DRN M6 DRN B 0 0.0480 0.1080)
C8_1 4:22 VSS:4 4.44601e-20
C8_2 4:23 VSS:4 4.52429e-20
C8_3 4:7 VSS:5 1.24235e-18
C8_4 4:22 VSS:5 1.00505e-19
C8_5 4:24 VSS:5 6.5796e-20
C8_6 M2:DRN VSS:11 1.74124e-20
C8_7 4:6 VSS:11 4.61602e-19
C8_8 4:7 VSS:11 6.97587e-19
C8_9 4:8 VSS:11 1.83918e-19
C8_10 4:12 VSS:11 2.53786e-18
C8_11 4:13 VSS:11 9.53961e-19
C8_12 4:22 VSS:11 4.86404e-19
C8_13 4:24 VSS:11 3.40549e-19
C8_14 4:11 VSS:14 8.89365e-19
C8_15 4:14 VSS:14 8.02586e-19
C8_16 4:22 VSS:14 3.28637e-19
C8_17 4:23 VSS:14 5.19542e-19
C8_18 4:24 VSS:14 2.54167e-19
C8_19 4:22 VSS:16 6.31876e-20
C8_20 4:24 VSS:16 8.37498e-20
C8_21 4:22 VSS:17 1.27336e-19
C8_22 4:6 VSS:19 1.00191e-19
C8_23 4:12 VSS:19 7.77461e-20
C8_24 4:22 VSS:19 6.99567e-18
C8_25 4:23 VSS:19 5.1708e-20
C8_26 4:24 VSS:19 8.30444e-20
C8_27 4:22 VSS:20 5.05156e-20
C8_28 4:23 VSS:20 6.33877e-20
C8_29 4:10 VDD 1.17207e-19
C8_30 4:11 VDD 2.91812e-19
C8_31 4:13 VDD 4.09483e-20
C8_32 4:22 VDD 6.3446e-19
C8_33 4:23 VDD 1.20683e-18
C8_34 4:24 VDD 5.47087e-19
C8_35 M6:DRN VDD:5 2.82443e-20
C8_36 4:23 VDD:5 8.37832e-20
C8_37 4:9 VDD:7 1.25618e-18
C8_38 4:8 VDD:12 1.83539e-19
C8_39 4:9 VDD:12 6.88271e-19
C8_40 4:10 VDD:12 3.72488e-19
C8_41 4:11 VDD:12 1.1946e-18
C8_42 4:13 VDD:12 1.65907e-18
C8_43 4:24 VDD:12 5.45996e-20
C8_44 4:11 VDD:17 2.13821e-20
C8_45 4:12 VDD:17 3.75819e-21
C8_46 4:14 VDD:17 2.82443e-20
C8_47 4:13 VDD:18 1.52324e-20
C8_48 4:12 VDD:19 1.22245e-19
C8_49 M6:DRN VDD:20 2.13821e-20
C8_50 4:23 VDD:20 9.95344e-20
C8_51 4:7 Y:12 1.4874e-19
C8_52 4:8 Y:12 2.27501e-19
C8_53 4:9 Y:12 1.99089e-19
C8_54 4:13 Y:12 2.90465e-19
C8_55 4:22 Y:12 7.52998e-19
C8_56 4:23 Y:12 6.36535e-20
C8_57 4:24 Y:12 1.85928e-18
C8_58 4:22 A:10 8.31609e-19
C8_59 4:23 A:10 3.63163e-18
C8_60 4:24 A:10 2.02752e-20
C8_61 4:22 B:4 1.67976e-20
C8_62 4:22 B:5 5.69373e-20
C8_63 4:23 B:5 8.05574e-20
C8_64 4:11 B:6 1.83918e-19
C8_65 4:22 B:6 1.24019e-19
C8_66 4:23 B:6 1.52249e-19
C8_67 4:12 B:8 8.31047e-19
C8_68 4:24 B:8 1.82924e-20
C8_69 M2:DRN B:10 7.01306e-22
C8_70 4:11 B:10 1.36475e-19
C8_71 4:12 B:10 3.51715e-19
C8_72 4:14 B:10 8.37832e-20
C8_73 4:15 B:10 2.36591e-21
C8_74 4:22 B:10 1.69189e-18
C8_75 4:23 B:10 3.04241e-18
C8_76 4:24 B:10 1.42497e-18
C8_77 4:22 M3:DRN 7.23364e-20
C8_78 4:23 M3:DRN 9.0937e-20
Cg8_79 4:6 VSS 1.00945e-19
Cg8_80 4:8 VSS 9.8281e-19
Cg8_81 4:10 VSS 1.68609e-19
Cg8_82 4:11 VSS 3.29032e-19
Cg8_83 4:12 VSS 2.75889e-19
Cg8_84 4:13 VSS 4.69737e-19
Cg8_85 4:14 VSS 2.52098e-19
Cg8_86 4:15 VSS 1.78742e-19
Cg8_87 4:22 VSS 1.27577e-18
Cg8_88 4:23 VSS 1.38893e-18
Cg8_89 4:24 VSS 8.41894e-19
R8_1 M1:GATE 4:7 7.57576
R8_2 M1:GATE 4:6 7.57576
R8_3 M2:DRN 4:15 30000.0
R8_4 M2:DRN 4:27 20270.3
R8_5 M2:DRN 4:12 57692.3
R8_6 M2:DRN 4:21 30000.0
R8_7 M4:GATE 4:9 7.57576
R8_8 M4:GATE 4:8 7.57576
R8_9 M5:SRC 4:14 30000.0
R8_10 M5:SRC 4:11 30000.0
R8_11 M5:SRC 4:19 15000.0
R8_12 M6:DRN 4:14 30000.0
R8_13 M6:DRN 4:11 30000.0
R8_14 M6:DRN 4:19 15000.0
R8_15 4:6 4:25 5.55556
R8_16 4:7 4:13 10.6061
R8_17 4:8 4:13 10.6061
R8_18 4:9 4:10 5.55556
R8_19 4:11 4:19 9.78705
R8_20 4:12 4:21 5.51688
R8_21 4:13 4:17 27.7339
R8_22 4:14 4:19 9.78705
R8_23 4:15 4:21 14.0605
R8_24 4:15 4:27 98999.9
R8_25 4:16 4:17 63.5281
R8_26 4:16 4:22 25.7999
R8_27 4:16 4:24 3.58332
R8_28 4:17 4:26 7.92396
R8_29 4:18 4:19 63.5281
R8_30 4:18 4:23 47.2998
R8_31 4:18 4:28 5.9722
R8_32 4:20 4:21 63.5281
R8_33 4:20 4:23 25.0832
R8_34 4:20 4:22 25.0832
R8_35 4:21 4:27 3.76373

*|NET _generated_11 2.86348e-06PF
C9_1 _generated_11:1 VSS:14 6.61239e-19
C9_2 _generated_11:1 VSS:19 2.25577e-20
C9_3 _generated_11:1 VSS:20 3.44976e-19
C9_4 _generated_11:1 A:10 3.06042e-19
Cg9_5 _generated_11:1 VSS 9.49624e-19
R9_1 _generated_11:1 _generated_11:2 28.2828

*|NET _generated_12 3.08088e-06PF
C10_1 _generated_12:1 VSS:11 1.47021e-19
C10_2 _generated_12:1 VSS:14 5.65589e-19
C10_3 _generated_12:1 VDD 4.89892e-20
C10_4 _generated_12:1 VDD:12 1.18927e-19
C10_5 _generated_12:1 VDD:20 3.74453e-19
C10_6 _generated_12:1 A:10 3.15962e-19
C10_7 _generated_12:1 _generated_11:1 5.79044e-19
Cg10_8 _generated_12:1 VSS 9.3089e-19
R10_1 _generated_12:1 _generated_12:2 28.2828

*|NET _generated_13 4.04634e-06PF
C11_1 _generated_13:1 VSS:11 9.11149e-19
C11_2 _generated_13:1 VSS:14 1.81545e-19
C11_3 _generated_13:1 VSS:19 5.03668e-20
C11_4 _generated_13:1 B:4 5.04539e-19
C11_5 _generated_13:1 4:6 3.12363e-20
C11_6 _generated_13:1 4:7 5.90193e-20
C11_7 _generated_13:1 4:8 8.51852e-20
C11_8 _generated_13:1 4:12 1.62514e-19
C11_9 _generated_13:1 4:22 2.00763e-19
C11_10 _generated_13:1 4:24 1.12303e-19
Cg11_11 _generated_13:1 VSS 1.16231e-18
R11_1 _generated_13:1 _generated_13:2 28.2828

*|NET _generated_14 3.1298e-06PF
C12_1 _generated_14:1 VSS:14 3.83516e-19
C12_2 _generated_14:1 VDD 9.67158e-20
C12_3 _generated_14:1 VDD:12 5.04617e-19
C12_4 _generated_14:1 4:8 1.82326e-19
C12_5 _generated_14:1 4:9 4.74065e-20
C12_6 _generated_14:1 4:10 3.10326e-20
C12_7 _generated_14:1 4:24 2.27958e-20
C12_8 _generated_14:1 _generated_13:1 5.85408e-19
Cg12_9 _generated_14:1 VSS 1.27598e-18
R12_1 _generated_14:1 _generated_14:2 28.2828

*|NET _generated_15 5.29687e-06PF
C13_1 _generated_15:1 VSS:11 4.72309e-19
C13_2 _generated_15:1 VSS:14 2.98844e-20
C13_3 _generated_15:1 VSS:19 6.14526e-20
C13_4 _generated_15:1 Y:4 3.81915e-19
C13_5 _generated_15:1 Y:12 5.41345e-20
C13_6 _generated_15:1 4:6 4.75026e-20
C13_7 _generated_15:1 4:8 2.39886e-19
Cg13_8 _generated_15:1 VSS 3.40563e-18
R13_1 _generated_15:1 _generated_15:2 28.2828

*|NET _generated_16 4.98745e-06PF
C14_1 _generated_16:1 VDD 2.13042e-19
C14_2 _generated_16:1 VDD:12 1.1978e-19
C14_3 _generated_16:1 Y:5 3.81915e-19
C14_4 _generated_16:1 Y:12 5.87117e-20
C14_5 _generated_16:1 4:8 2.39886e-19
C14_6 _generated_16:1 4:10 4.75026e-20
C14_7 _generated_16:1 _generated_15:1 6.0415e-19
Cg14_8 _generated_16:1 VSS 3.32246e-18
R14_1 _generated_16:1 _generated_16:2 28.2828

*
* Instance Section
*
MM1 M1:DRN M1:GATE M1:SRC VSS NMOS_LVT l=0.012u w=0.03u NF=1
MM2 M2:DRN M2:GATE M2:SRC VSS NMOS_LVT l=0.012u w=0.03u NF=1
MM3 M3:DRN M3:GATE M3:SRC VSS NMOS_LVT l=0.012u w=0.03u NF=1
MM4 M4:DRN M4:GATE M4:SRC VDD PMOS_LVT l=0.012u w=0.03u NF=1
MM5 M5:DRN M5:GATE M5:SRC VDD PMOS_LVT l=0.012u w=0.03u NF=1
MM6 M6:DRN M6:GATE M6:SRC VDD PMOS_LVT l=0.012u w=0.03u NF=1

.ENDS
