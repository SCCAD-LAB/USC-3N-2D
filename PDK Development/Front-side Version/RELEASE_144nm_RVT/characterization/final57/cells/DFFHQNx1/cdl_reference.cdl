* CANDIDATE independent circuit from preserved2024 prior-layout DSPF.
* All resistive segments collapsed to ideal wires; capacitors omitted for LVS topology.
* Not extracted from the new144nmDUT. Requires independent review before gold admission.
* Source /cedar/cedar_coe/ece-limsk/sw.jung/pdk/LIB_issue_fix/final_w17_pdk/1_fspr/10_liberate_final_fspr_rvt/NETLIST/DFFHQNx1.spf
.SUBCKT DFFHQNx1 CK D QN VDD VSS
MMM17 QN MM10:DRN VSS nmos_rvt l=0.012u w=0.03u
MMM7 MM6:SRC D VSS nmos_rvt l=0.012u w=0.03u
MMM1 MM10:GATE MM0:DRN VSS nmos_rvt l=0.012u w=0.03u
MMM0 MM0:DRN CK VSS nmos_rvt l=0.012u w=0.03u
MMM16 QN MM10:DRN VDD pmos_rvt l=0.012u w=0.03u
MMM18 MM18:DRN MM10:DRN VDD pmos_rvt l=0.012u w=0.015u
MMM20 MM20:DRN MM18:DRN VDD pmos_rvt l=0.012u w=0.015u
MMM21 MM10:DRN MM10:GATE MM20:DRN pmos_rvt l=0.012u w=0.015u
MMM9 MM10:DRN MM0:DRN MM10:SRC pmos_rvt l=0.012u w=0.015u
MMM8 MM10:SRC MM11:GATE VDD pmos_rvt l=0.012u w=0.015u
MMM12 MM12:DRN MM10:SRC VDD pmos_rvt l=0.012u w=0.015u
MMM19 MM18:DRN MM10:DRN VSS nmos_rvt l=0.012u w=0.015u
MMM13 MM11:GATE MM0:DRN MM12:DRN pmos_rvt l=0.012u w=0.015u
MMM5 MM11:GATE MM10:GATE MM4:DRN pmos_rvt l=0.012u w=0.03u
MMM4 MM4:DRN D VDD pmos_rvt l=0.012u w=0.03u
MMM3 MM10:GATE MM0:DRN VDD pmos_rvt l=0.012u w=0.03u
MMM2 MM0:DRN CK VDD pmos_rvt l=0.012u w=0.03u
MMM23 MM22:SRC MM18:DRN VSS nmos_rvt l=0.012u w=0.015u
MMM22 MM10:DRN MM0:DRN MM22:SRC nmos_rvt l=0.012u w=0.015u
MMM10 MM10:DRN MM10:GATE MM10:SRC nmos_rvt l=0.012u w=0.015u
MMM11 MM10:SRC MM11:GATE VSS nmos_rvt l=0.012u w=0.015u
MMM15 MM14:SRC MM10:SRC VSS nmos_rvt l=0.012u w=0.015u
MMM14 MM11:GATE MM10:GATE MM14:SRC nmos_rvt l=0.012u w=0.015u
MMM6 MM11:GATE MM0:DRN MM6:SRC nmos_rvt l=0.012u w=0.03u
.ends DFFHQNx1
