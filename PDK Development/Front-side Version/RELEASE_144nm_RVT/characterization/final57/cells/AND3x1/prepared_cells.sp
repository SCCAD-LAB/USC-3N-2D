*
*|DSPF 1.3
*|DESIGN AND3x1
*|DATE "Tue Nov  3 20:50:54 2026"
*|VENDOR "Synopsys"
*|PROGRAM "StarRC"
*|VERSION "X-2025.06-SP1"
*|DIVIDER /
*|DELIMITER :
**FORMAT SPF
*

** COMMENTS

** OPERATING_TEMPERATURE 25
** GLOBAL_TEMPERATURE 25
**
** TCAD_GRD_FILE /cedar/cedar_coe/ece-limsk/yhuang861/GRO/.planning/experiments_migrated_20261022/usc144_github_release_20261103/sources/github_FSPR.nxtgrd
**   TCAD_TIME_STAMP Tue Mar 31 05:07:55 2026
**   TCADGRD_VERSION 89

.SUBCKT AND3x1 VSS VDD Y A B C

*|GROUND_NET VSS

*|NET VSS 9.23337e-05PF
*|P (VSS B 0 0.1260 0.0000)
*|I (M1:SRC M1 SRC B 0 0.2040 0.0360)
*|I (M4:SRC M4 SRC B 0 0.0360 0.0360)
Cg1_1 VSS:4 VSS 2.52098e-19
Cg1_2 VSS:5 VSS 1.90317e-19
Cg1_3 VSS:14 VSS 2.7518e-18
Cg1_4 VSS:17 VSS 3.47903e-17
Cg1_5 VSS:20 VSS 4.54108e-18
Cg1_6 VSS:22 VSS 7.77773e-18
Cg1_7 VSS:23 VSS 5.2628e-19
R1_1 VSS VSS:11 12.5416
R1_2 VSS VSS:9 12.5416
R1_3 M1:SRC VSS:19 30000.0
R1_4 M1:SRC VSS:5 30000.0
R1_5 M1:SRC VSS:28 15000.0
R1_6 M4:SRC VSS:18 30000.0
R1_7 M4:SRC VSS:4 30000.0
R1_8 M4:SRC VSS:26 15000.0
R1_9 VSS:4 VSS:26 7.8411
R1_10 VSS:4 VSS:23 12.4587
R1_11 VSS:5 VSS:28 7.8411
R1_12 VSS:5 VSS:14 12.4587
R1_13 VSS:6 VSS:22 17.9166
R1_14 VSS:6 VSS:7 25.0832
R1_15 VSS:6 VSS:23 31.764
R1_16 VSS:7 VSS:8 63.5281
R1_17 VSS:7 VSS:9 25.0832
R1_18 VSS:8 VSS:23 50.1851
R1_19 VSS:8 VSS:10 55.4677
R1_20 VSS:9 VSS:10 63.5281
R1_21 VSS:10 VSS:12 55.4677
R1_22 VSS:11 VSS:12 63.5281
R1_23 VSS:11 VSS:13 25.0832
R1_24 VSS:12 VSS:14 50.1851
R1_25 VSS:13 VSS:14 31.764
R1_26 VSS:13 VSS:15 25.0832
R1_27 VSS:14 VSS:16 50.1851
R1_28 VSS:15 VSS:16 63.5281
R1_29 VSS:15 VSS:30 17.9166
R1_30 VSS:16 VSS:25 39.6198
R1_31 VSS:17 VSS:20 7778.54
R1_32 VSS:18 VSS:26 7.8411
R1_33 VSS:18 VSS:27 1.77981
R1_34 VSS:19 VSS:28 7.8411
R1_35 VSS:19 VSS:29 1.77981
R1_36 VSS:20 VSS:21 2332.32
R1_37 VSS:23 VSS:24 34.3372
R1_38 VSS:23 VSS:17 0.01

*|NET VDD 5.86895e-05PF
*|P (VDD B 0 0.1260 0.1440)
*|I (M5:SRC M5 SRC B 0 0.2040 0.1080)
*|I (M6:SRC M6 SRC B 0 0.1200 0.1080)
*|I (M7:DRN M7 DRN B 0 0.0900 0.1080)
*|I (M8:SRC M8 SRC B 0 0.0360 0.1080)
C2_1 VDD VSS:14 7.79004e-20
C2_2 VDD:16 VSS:14 1.66467e-19
C2_3 VDD:19 VSS:14 6.70874e-21
C2_4 VDD:22 VSS:14 4.01983e-21
C2_5 VDD:24 VSS:14 6.38861e-20
C2_6 VDD VSS:17 1.55584e-18
C2_7 VDD:6 VSS:17 8.02899e-19
C2_8 VDD:7 VSS:17 8.00234e-19
C2_9 VDD:16 VSS:17 3.57233e-19
C2_10 VDD:23 VSS:17 1.2937e-18
C2_11 VDD:24 VSS:17 1.49995e-18
C2_12 VDD VSS:22 1.13851e-18
C2_13 VDD:16 VSS:22 2.76282e-20
C2_14 VDD VSS:23 8.78916e-22
C2_15 VDD:19 VSS:23 3.86285e-21
C2_16 VDD:24 VSS:23 1.20446e-19
Cg2_17 VDD VSS 7.88238e-18
Cg2_18 VDD:6 VSS 2.76091e-19
Cg2_19 VDD:7 VSS 2.41358e-19
Cg2_20 VDD:8 VSS 1.90317e-19
Cg2_21 VDD:16 VSS 1.31803e-17
Cg2_22 VDD:19 VSS 5.43919e-21
Cg2_23 VDD:22 VSS 5.43766e-21
Cg2_24 VDD:23 VSS 7.69247e-19
Cg2_25 VDD:24 VSS 8.29438e-19
R2_1 VDD VDD:12 12.5416
R2_2 VDD VDD:13 12.5416
R2_3 VDD VDD:20 47328.0
R2_4 M5:SRC VDD:22 30000.0
R2_5 M5:SRC VDD:8 30000.0
R2_6 M5:SRC VDD:31 15000.0
R2_7 M6:SRC VDD:21 30000.0
R2_8 M6:SRC VDD:7 30000.0
R2_9 M6:SRC VDD:29 15000.0
R2_10 M7:DRN VDD:21 30000.0
R2_11 M7:DRN VDD:7 30000.0
R2_12 M7:DRN VDD:29 15000.0
R2_13 M8:SRC VDD:19 30000.0
R2_14 M8:SRC VDD:6 30000.0
R2_15 M8:SRC VDD:27 15000.0
R2_16 VDD:6 VDD:27 7.8411
R2_17 VDD:6 VDD:28 1.77981
R2_18 VDD:7 VDD:29 7.84041
R2_19 VDD:7 VDD:30 1.77981
R2_20 VDD:8 VDD:31 7.8411
R2_21 VDD:8 VDD:32 1.77981
R2_22 VDD:9 VDD:33 17.9166
R2_23 VDD:9 VDD:10 25.0832
R2_24 VDD:9 VDD:24 31.764
R2_25 VDD:10 VDD:11 63.5281
R2_26 VDD:10 VDD:12 25.0832
R2_27 VDD:11 VDD:24 50.1851
R2_28 VDD:11 VDD:23 50.1851
R2_29 VDD:12 VDD:23 31.764
R2_30 VDD:13 VDD:14 63.5281
R2_31 VDD:13 VDD:15 25.0832
R2_32 VDD:14 VDD:23 50.1851
R2_33 VDD:14 VDD:16 50.1851
R2_34 VDD:15 VDD:16 31.764
R2_35 VDD:15 VDD:17 25.0832
R2_36 VDD:16 VDD:18 50.1851
R2_37 VDD:16 VDD:22 12.4587
R2_38 VDD:17 VDD:18 63.5281
R2_39 VDD:17 VDD:34 17.9166
R2_40 VDD:18 VDD:26 39.6198
R2_41 VDD:19 VDD:27 7.8411
R2_42 VDD:19 VDD:24 12.4587
R2_43 VDD:21 VDD:29 7.84041
R2_44 VDD:21 VDD:23 12.4587
R2_45 VDD:22 VDD:31 7.8411
R2_46 VDD:24 VDD:25 34.3372

*|NET Y 1.73254e-05PF
*|P (Y B 0 0.2310 0.0720)
*|I (M1:DRN M1 DRN B 0 0.2160 0.0360)
*|I (M5:DRN M5 DRN B 0 0.2160 0.1080)
C3_1 M1:DRN VSS:5 3.78986e-20
C3_2 Y:12 VSS:5 1.77132e-19
C3_3 M1:DRN VSS:14 5.55438e-20
C3_4 Y:4 VSS:14 2.32339e-18
C3_5 Y:12 VSS:14 1.86634e-19
C3_6 Y:12 VSS:17 6.02473e-19
C3_7 Y:12 VSS:20 7.77805e-20
C3_8 Y:12 VSS:21 1.98849e-19
C3_9 Y:4 VSS:22 1.84985e-19
C3_10 Y:12 VSS:22 1.43102e-18
C3_11 Y:5 VDD 2.85537e-19
C3_12 Y:12 VDD 1.43894e-18
C3_13 M5:DRN VDD:8 3.78986e-20
C3_14 Y:12 VDD:8 1.77132e-19
C3_15 M5:DRN VDD:16 6.2592e-20
C3_16 Y:5 VDD:16 1.05946e-18
C3_17 Y:12 VDD:16 3.05127e-19
Cg3_18 Y:4 VSS 3.15906e-19
Cg3_19 Y:5 VSS 2.8933e-19
Cg3_20 Y:6 VSS 1.78742e-19
Cg3_21 Y:7 VSS 1.78742e-19
Cg3_22 Y:12 VSS 3.30264e-18
R3_1 Y Y:10 21.4999
R3_2 Y Y:8 21.4999
R3_3 M1:DRN Y:6 30000.0
R3_4 M1:DRN Y:4 30000.0
R3_5 M1:DRN Y:9 15000.0
R3_6 M5:DRN Y:7 30000.0
R3_7 M5:DRN Y:5 30000.0
R3_8 M5:DRN Y:11 15000.0
R3_9 Y:4 Y:9 9.78801
R3_10 Y:5 Y:11 9.78801
R3_11 Y:6 Y:9 9.78801
R3_12 Y:7 Y:11 9.78801
R3_13 Y:8 Y:9 63.5281
R3_14 Y:8 Y:12 7.8833
R3_15 Y:10 Y:11 63.5281
R3_16 Y:10 Y:13 7.94303

*|NET A 1.83513e-05PF
*|P (A B 0 0.0210 0.0720)
*|I (M4:GATE M4 GATE I 3.6e-19 0.0420 0.0360)
*|I (M8:GATE M8 GATE I 3.6e-19 0.0420 0.1080)
C4_1 A:10 VSS:4 2.33814e-19
C4_2 A:4 VSS:14 4.61602e-19
C4_3 A:5 VSS:14 7.89427e-21
C4_4 A:10 VSS:14 9.63817e-20
C4_5 A:10 VSS:17 9.51583e-19
C4_6 A:10 VSS:18 4.85975e-20
C4_7 A:4 VSS:22 2.34888e-20
C4_8 A:10 VSS:22 1.47343e-18
C4_9 A:8 VSS:23 9.16124e-19
C4_10 A:10 VSS:23 6.15563e-19
C4_11 A:4 VDD 4.02543e-21
C4_12 A:7 VDD 4.44318e-20
C4_13 A:8 VDD 2.83023e-20
C4_14 A:10 VDD 1.48127e-18
C4_15 A:10 VDD:6 1.1494e-19
C4_16 A:7 VDD:16 1.15802e-19
C4_17 A:8 VDD:19 1.48933e-20
C4_18 A:10 VDD:19 1.17795e-19
C4_19 A:8 VDD:24 1.58128e-18
C4_20 A:10 VDD:24 4.73109e-19
Cg4_21 A:4 VSS 1.09486e-19
Cg4_22 A:6 VSS 3.4119e-19
Cg4_23 A:7 VSS 2.31874e-19
Cg4_24 A:8 VSS 1.99342e-19
Cg4_25 A:10 VSS 3.73001e-18
R4_1 A A:10 29.3832
R4_2 A A:13 29.4429
R4_3 A A:9 63.5281
R4_4 M4:GATE A:5 7.57576
R4_5 M4:GATE A:4 7.57576
R4_6 M8:GATE A:7 13.1313
R4_7 M8:GATE A:6 7.57576
R4_8 A:4 A:11 5.55556
R4_9 A:5 A:8 10.6061
R4_10 A:6 A:8 10.6061
R4_11 A:8 A:9 27.7339
R4_12 A:9 A:12 7.92396

*|NET B 1.62064e-05PF
*|P (B B 0 0.0630 0.0720)
*|I (M3:GATE M3 GATE I 3.6e-19 0.0840 0.0360)
*|I (M7:GATE M7 GATE I 3.6e-19 0.0840 0.1080)
C5_1 B:11 VSS:4 8.37832e-20
C5_2 B:4 VSS:14 4.61602e-19
C5_3 B:5 VSS:14 7.89427e-21
C5_4 B:11 VSS:14 8.83916e-20
C5_5 B:11 VSS:17 4.01701e-19
C5_6 B:11 VSS:22 1.69746e-18
C5_7 B:11 VSS:23 1.07916e-19
C5_8 B:11 A:10 3.2141e-18
Cg5_9 B:4 VSS 1.09232e-19
Cg5_10 B:6 VSS 3.4119e-19
Cg5_11 B:8 VSS 3.84125e-19
Cg5_12 B:9 VSS 1.743e-19
Cg5_13 B:11 VSS 1.86653e-18
R5_1 B B:11 29.3832
R5_2 B B:14 12.8402
R5_3 B B:10 63.5281
R5_4 M3:GATE B:5 7.57576
R5_5 M3:GATE B:4 7.57576
R5_6 M7:GATE B:7 7.57576
R5_7 M7:GATE B:6 7.57576
R5_8 B:4 B:12 5.55556
R5_9 B:5 B:9 10.6061
R5_10 B:6 B:9 10.6061
R5_11 B:7 B:8 5.55556
R5_12 B:9 B:10 27.7339
R5_13 B:10 B:13 7.92396

*|NET C 1.69677e-05PF
*|P (C B 0 0.1050 0.0720)
*|I (M2:GATE M2 GATE I 3.6e-19 0.1260 0.0360)
*|I (M6:GATE M6 GATE I 3.6e-19 0.1260 0.1080)
C6_1 C:4 VSS:14 4.76741e-19
C6_2 C:5 VSS:14 7.89427e-21
C6_3 C:11 VSS:14 8.83916e-20
C6_4 C:11 VSS:17 3.45371e-19
C6_5 C:4 VSS:22 4.00386e-20
C6_6 C:11 VSS:22 1.63161e-18
C6_7 C:8 VDD 5.14487e-20
C6_8 C:11 VDD 1.39836e-19
C6_9 C:8 VDD:16 1.15217e-19
C6_10 C:9 VDD:21 1.71158e-20
C6_11 C:6 VDD:23 1.83918e-19
C6_12 C:9 VDD:23 1.62973e-18
C6_13 C:11 VDD:23 1.12105e-19
C6_14 C:11 B:11 3.15556e-18
Cg6_15 C:4 VSS 2.2589e-19
Cg6_16 C:6 VSS 3.4119e-19
Cg6_17 C:8 VSS 2.27134e-19
Cg6_18 C:9 VSS 1.63308e-19
Cg6_19 C:11 VSS 1.88343e-18
R6_1 C C:11 29.3832
R6_2 C C:14 12.8402
R6_3 C C:10 63.5281
R6_4 M2:GATE C:5 7.57576
R6_5 M2:GATE C:4 7.57576
R6_6 M6:GATE C:7 7.57576
R6_7 M6:GATE C:6 7.57576
R6_8 C:4 C:12 5.55556
R6_9 C:5 C:9 10.6061
R6_10 C:6 C:9 10.6061
R6_11 C:7 C:8 5.55556
R6_12 C:9 C:10 27.7339
R6_13 C:10 C:13 7.92396

*|NET 11 6.68567e-07PF
*|I (M3:SRC M3 SRC B 0 0.0780 0.0360)
*|I (M4:DRN M4 DRN B 0 0.0480 0.0360)
C8_1 M4:DRN VSS:4 2.82443e-20
C8_2 M4:DRN VSS:14 4.65606e-19
C8_3 M4:DRN VSS:22 4.7038e-20
C8_4 M4:DRN VSS:23 2.13821e-20
C8_5 M4:DRN B:11 1.06296e-19
R8_1 M3:SRC M4:DRN 15000.0

*|NET 12 7.04613e-07PF
*|I (M2:SRC M2 SRC B 0 0.1200 0.0360)
*|I (M3:DRN M3 DRN B 0 0.0900 0.0360)
C9_1 M3:DRN VSS:14 4.65606e-19
C9_2 M3:DRN VSS:22 8.79517e-20
C9_3 M3:DRN C:11 1.51055e-19
R9_1 M2:SRC M3:DRN 15000.0

*|NET 4 5.18758e-05PF
*|I (M1:GATE M1 GATE I 3.6e-19 0.2100 0.0360)
*|I (M2:DRN M2 DRN B 0 0.1320 0.0360)
*|I (M5:GATE M5 GATE I 3.6e-19 0.2100 0.1080)
*|I (M6:DRN M6 DRN B 0 0.1320 0.1080)
*|I (M7:SRC M7 SRC B 0 0.0780 0.1080)
*|I (M8:DRN M8 DRN B 0 0.0480 0.1080)
C10_1 4:8 VSS:5 1.25618e-18
C10_2 M2:DRN VSS:14 1.73349e-20
C10_3 4:7 VSS:14 7.19388e-19
C10_4 4:8 VSS:14 7.08412e-19
C10_5 4:9 VSS:14 1.86805e-19
C10_6 4:13 VSS:14 2.60151e-18
C10_7 4:15 VSS:14 9.91502e-19
C10_8 4:28 VSS:14 6.5361e-20
C10_9 4:29 VSS:14 4.46938e-19
C10_10 4:12 VSS:17 1.06604e-18
C10_11 4:16 VSS:17 8.02037e-19
C10_12 4:27 VSS:17 4.76891e-19
C10_13 4:28 VSS:17 3.77571e-19
C10_14 4:29 VSS:17 3.09734e-19
C10_15 4:28 VSS:20 6.75265e-20
C10_16 4:7 VSS:22 4.2697e-20
C10_17 4:13 VSS:22 1.89933e-19
C10_18 4:27 VSS:22 6.30882e-19
C10_19 4:28 VSS:22 1.15396e-18
C10_20 4:29 VSS:22 9.52371e-19
C10_21 4:11 VDD 1.17207e-19
C10_22 4:12 VDD 1.80686e-19
C10_23 4:14 VDD 2.57625e-19
C10_24 4:15 VDD 4.09483e-20
C10_25 4:27 VDD 6.98515e-18
C10_26 4:28 VDD 5.29526e-20
C10_27 4:29 VDD 9.33827e-19
C10_28 M8:DRN VDD:6 2.82443e-20
C10_29 4:27 VDD:6 6.02467e-20
C10_30 M6:DRN VDD:7 3.01108e-20
C10_31 4:27 VDD:7 1.59635e-19
C10_32 4:28 VDD:7 4.96057e-20
C10_33 4:10 VDD:8 1.25618e-18
C10_34 4:9 VDD:16 1.83539e-19
C10_35 4:10 VDD:16 6.88271e-19
C10_36 4:11 VDD:16 3.72488e-19
C10_37 4:12 VDD:16 1.19561e-18
C10_38 4:14 VDD:16 1.06277e-18
C10_39 4:15 VDD:16 1.65907e-18
C10_40 4:29 VDD:16 1.03863e-19
C10_41 4:12 VDD:21 2.48114e-20
C10_42 4:16 VDD:21 3.01108e-20
C10_43 4:27 VDD:21 5.44158e-20
C10_44 4:15 VDD:22 1.52324e-20
C10_45 M6:DRN VDD:23 4.16022e-20
C10_46 4:27 VDD:23 5.93804e-19
C10_47 4:28 VDD:23 7.82117e-20
C10_48 M8:DRN VDD:24 2.13821e-20
C10_49 4:27 VDD:24 6.53731e-20
C10_50 4:8 Y:12 2.19599e-19
C10_51 4:9 Y:12 2.30271e-19
C10_52 4:10 Y:12 1.95671e-19
C10_53 4:15 Y:12 2.90465e-19
C10_54 4:27 Y:12 4.26296e-19
C10_55 4:28 Y:12 1.48213e-18
C10_56 4:29 Y:12 6.95271e-19
C10_57 4:27 A:10 9.76393e-19
C10_58 4:28 A:10 1.22614e-19
C10_59 4:27 B:4 4.32832e-21
C10_60 4:27 B:6 5.11476e-20
C10_61 4:27 B:7 5.16341e-20
C10_62 4:27 B:8 1.9335e-20
C10_63 M8:DRN B:9 1.71316e-20
C10_64 4:12 B:9 1.6205e-18
C10_65 4:27 B:9 1.24808e-19
C10_66 4:12 B:11 1.03961e-19
C10_67 4:27 B:11 1.68759e-18
C10_68 4:28 B:11 2.96747e-19
C10_69 4:29 B:11 2.91594e-20
C10_70 4:28 C:5 1.33321e-19
C10_71 4:27 C:6 5.62864e-20
C10_72 4:28 C:6 1.1565e-19
C10_73 4:27 C:7 5.16341e-20
C10_74 4:27 C:8 1.9335e-20
C10_75 4:27 C:9 1.23172e-19
C10_76 4:29 C:9 1.84403e-19
C10_77 4:12 C:11 3.53609e-20
C10_78 4:16 C:11 1.53602e-20
C10_79 4:27 C:11 1.64174e-18
C10_80 4:28 C:11 2.66401e-18
C10_81 4:29 C:11 4.31311e-19
Cg10_82 4:7 VSS 1.00945e-19
Cg10_83 4:9 VSS 9.8281e-19
Cg10_84 4:11 VSS 1.68609e-19
Cg10_85 4:12 VSS 3.35981e-19
Cg10_86 4:13 VSS 3.00702e-19
Cg10_87 4:14 VSS 2.37187e-19
Cg10_88 4:15 VSS 4.69737e-19
Cg10_89 4:16 VSS 2.55987e-19
Cg10_90 4:17 VSS 1.78742e-19
Cg10_91 4:18 VSS 1.78742e-19
Cg10_92 4:27 VSS 1.40851e-18
Cg10_93 4:28 VSS 1.50991e-18
Cg10_94 4:29 VSS 8.33742e-19
R10_1 M1:GATE 4:8 7.57576
R10_2 M1:GATE 4:7 7.57576
R10_3 M2:DRN 4:13 30000.0
R10_4 M2:DRN 4:17 30000.0
R10_5 M2:DRN 4:24 15000.0
R10_6 M5:GATE 4:10 7.57576
R10_7 M5:GATE 4:9 7.57576
R10_8 M6:DRN 4:14 30000.0
R10_9 M6:DRN 4:18 30000.0
R10_10 M6:DRN 4:26 15000.0
R10_11 M7:SRC 4:12 30000.0
R10_12 M7:SRC 4:32 20089.3
R10_13 M7:SRC 4:16 59210.5
R10_14 M7:SRC 4:22 30000.0
R10_15 M8:DRN 4:12 30000.0
R10_16 M8:DRN 4:32 20089.3
R10_17 M8:DRN 4:16 59210.5
R10_18 M8:DRN 4:22 30000.0
R10_19 4:7 4:30 5.55556
R10_20 4:8 4:15 10.6061
R10_21 4:9 4:15 10.6061
R10_22 4:10 4:11 5.55556
R10_23 4:12 4:22 14.1199
R10_24 4:12 4:32 8.62446
R10_25 4:13 4:24 9.78801
R10_26 4:14 4:26 9.78801
R10_27 4:15 4:20 27.7339
R10_28 4:16 4:22 5.45702
R10_29 4:17 4:24 9.78801
R10_30 4:18 4:26 9.78801
R10_31 4:19 4:20 63.5281
R10_32 4:19 4:28 25.0832
R10_33 4:19 4:29 3.58332
R10_34 4:20 4:31 7.92396
R10_35 4:21 4:22 63.5281
R10_36 4:21 4:33 3.58332
R10_37 4:21 4:27 50.1665
R10_38 4:22 4:32 21900.0
R10_39 4:23 4:24 63.5281
R10_40 4:23 4:34 5.9722
R10_41 4:23 4:28 21.4999
R10_42 4:25 4:26 63.5281
R10_43 4:25 4:28 21.4999
R10_44 4:25 4:27 4.35971

*|NET _generated_13 2.86348e-06PF
C11_1 _generated_13:1 VSS:17 6.61239e-19
C11_2 _generated_13:1 VSS:22 2.25577e-20
C11_3 _generated_13:1 VSS:23 3.44976e-19
C11_4 _generated_13:1 A:10 3.06042e-19
Cg11_5 _generated_13:1 VSS 9.49624e-19
R11_1 _generated_13:1 _generated_13:2 28.2828

*|NET _generated_14 3.08088e-06PF
C12_1 _generated_14:1 VSS:14 1.47021e-19
C12_2 _generated_14:1 VSS:17 5.65589e-19
C12_3 _generated_14:1 VDD 4.89892e-20
C12_4 _generated_14:1 VDD:16 1.18927e-19
C12_5 _generated_14:1 VDD:24 3.74453e-19
C12_6 _generated_14:1 A:10 3.15962e-19
C12_7 _generated_14:1 _generated_13:1 5.79044e-19
Cg12_8 _generated_14:1 VSS 9.3089e-19
R12_1 _generated_14:1 _generated_14:2 28.2828

*|NET _generated_15 3.959e-06PF
C13_1 _generated_15:1 VSS:14 9.232e-19
C13_2 _generated_15:1 VSS:17 1.76795e-19
C13_3 _generated_15:1 VSS:22 6.6072e-20
C13_4 _generated_15:1 C:4 5.09167e-19
C13_5 _generated_15:1 M6:DRN 5.43766e-21
C13_6 _generated_15:1 4:7 3.12363e-20
C13_7 _generated_15:1 4:8 4.74065e-20
C13_8 _generated_15:1 4:9 9.05603e-20
C13_9 _generated_15:1 4:13 1.66608e-19
C13_10 _generated_15:1 4:29 1.76955e-19
Cg13_11 _generated_15:1 VSS 1.18589e-18
R13_1 _generated_15:1 _generated_15:2 28.2828

*|NET _generated_16 3.1427e-06PF
C14_1 _generated_16:1 VSS:17 3.79868e-19
C14_2 _generated_16:1 VDD 1.10572e-19
C14_3 _generated_16:1 VDD:16 5.04056e-19
C14_4 _generated_16:1 4:9 1.82326e-19
C14_5 _generated_16:1 4:10 4.74065e-20
C14_6 _generated_16:1 4:11 3.10326e-20
C14_7 _generated_16:1 4:29 3.77838e-20
C14_8 _generated_16:1 _generated_15:1 5.79666e-19
Cg14_9 _generated_16:1 VSS 1.26999e-18
R14_1 _generated_16:1 _generated_16:2 28.2828

*|NET _generated_17 5.30859e-06PF
C15_1 _generated_17:1 VSS:14 4.62142e-19
C15_2 _generated_17:1 VSS:17 2.98844e-20
C15_3 _generated_17:1 VSS:22 8.26703e-20
C15_4 _generated_17:1 Y:4 3.81915e-19
C15_5 _generated_17:1 Y:12 5.48053e-20
C15_6 _generated_17:1 4:7 4.75026e-20
C15_7 _generated_17:1 4:9 2.39886e-19
Cg15_8 _generated_17:1 VSS 3.40563e-18
R15_1 _generated_17:1 _generated_17:2 28.2828

*|NET _generated_18 4.95272e-06PF
C16_1 _generated_18:1 VDD 1.77679e-19
C16_2 _generated_18:1 VDD:16 1.1978e-19
C16_3 _generated_18:1 Y:5 3.81915e-19
C16_4 _generated_18:1 Y:12 5.9343e-20
C16_5 _generated_18:1 4:9 2.39886e-19
C16_6 _generated_18:1 4:11 4.75026e-20
C16_7 _generated_18:1 _generated_17:1 6.0415e-19
Cg16_8 _generated_18:1 VSS 3.32246e-18
R16_1 _generated_18:1 _generated_18:2 28.2828

*
* Instance Section
*
MM1 M1:DRN M1:GATE M1:SRC VSS NMOS_LVT l=0.012u w=0.03u NF=1
MM2 M2:DRN M2:GATE M2:SRC VSS NMOS_LVT l=0.012u w=0.03u NF=1
MM3 M3:DRN M3:GATE M3:SRC VSS NMOS_LVT l=0.012u w=0.03u NF=1
MM4 M4:DRN M4:GATE M4:SRC VSS NMOS_LVT l=0.012u w=0.03u NF=1
MM5 M5:DRN M5:GATE M5:SRC VDD PMOS_LVT l=0.012u w=0.03u NF=1
MM6 M6:DRN M6:GATE M6:SRC VDD PMOS_LVT l=0.012u w=0.03u NF=1
MM7 M7:DRN M7:GATE M7:SRC VDD PMOS_LVT l=0.012u w=0.03u NF=1
MM8 M8:DRN M8:GATE M8:SRC VDD PMOS_LVT l=0.012u w=0.03u NF=1

.ENDS
