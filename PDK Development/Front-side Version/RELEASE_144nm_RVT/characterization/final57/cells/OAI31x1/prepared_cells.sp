*
*|DSPF 1.3
*|DESIGN OAI31x1
*|DATE "Tue Nov  3 20:53:49 2026"
*|VENDOR "Synopsys"
*|PROGRAM "StarRC"
*|VERSION "X-2025.06-SP1"
*|DIVIDER /
*|DELIMITER :
**FORMAT SPF
*

** COMMENTS

** OPERATING_TEMPERATURE 25
** GLOBAL_TEMPERATURE 25
**
** TCAD_GRD_FILE /cedar/cedar_coe/ece-limsk/yhuang861/GRO/.planning/experiments_migrated_20261022/usc144_github_release_20261103/sources/github_FSPR.nxtgrd
**   TCAD_TIME_STAMP Tue Mar 31 05:07:55 2026
**   TCADGRD_VERSION 89

.SUBCKT OAI31x1 VSS VDD Y A B C D

*|GROUND_NET VSS

*|NET VSS 8.5226e-05PF
*|P (VSS B 0 0.1050 0.0000)
*|I (M2:SRC M2 SRC B 0 0.1200 0.0360)
*|I (M3:DRN M3 DRN B 0 0.0900 0.0360)
*|I (M4:SRC M4 SRC B 0 0.0360 0.0360)
Cg1_1 VSS:5 VSS 2.60582e-19
Cg1_2 VSS:6 VSS 2.65379e-19
Cg1_3 VSS:10 VSS 2.53321e-18
Cg1_4 VSS:15 VSS 3.102e-17
Cg1_5 VSS:18 VSS 5.08816e-18
Cg1_6 VSS:20 VSS 7.13949e-18
Cg1_7 VSS:21 VSS 5.32932e-19
R1_1 VSS VSS:8 25.0832
R1_2 VSS VSS:11 25.0832
R1_3 VSS VSS:10 31.764
R1_4 M2:SRC VSS:17 30000.0
R1_5 M2:SRC VSS:6 30000.0
R1_6 M2:SRC VSS:26 15000.0
R1_7 M3:DRN VSS:17 30000.0
R1_8 M3:DRN VSS:6 30000.0
R1_9 M3:DRN VSS:26 15000.0
R1_10 M4:SRC VSS:16 30000.0
R1_11 M4:SRC VSS:5 30000.0
R1_12 M4:SRC VSS:24 15000.0
R1_13 VSS:5 VSS:24 7.8411
R1_14 VSS:5 VSS:21 12.4587
R1_15 VSS:6 VSS:26 7.84041
R1_16 VSS:6 VSS:10 12.4587
R1_17 VSS:7 VSS:20 17.9166
R1_18 VSS:7 VSS:8 25.0832
R1_19 VSS:7 VSS:21 31.764
R1_20 VSS:8 VSS:9 63.5281
R1_21 VSS:9 VSS:21 50.1851
R1_22 VSS:9 VSS:10 50.1851
R1_23 VSS:10 VSS:12 50.1851
R1_24 VSS:11 VSS:12 63.5281
R1_25 VSS:11 VSS:13 25.0832
R1_26 VSS:12 VSS:14 55.4677
R1_27 VSS:13 VSS:14 63.5281
R1_28 VSS:13 VSS:28 17.9166
R1_29 VSS:14 VSS:23 39.6198
R1_30 VSS:15 VSS:18 7778.54
R1_31 VSS:16 VSS:24 7.8411
R1_32 VSS:16 VSS:25 1.77981
R1_33 VSS:17 VSS:26 7.84041
R1_34 VSS:17 VSS:27 1.77981
R1_35 VSS:18 VSS:19 3246.95
R1_36 VSS:21 VSS:22 34.3372
R1_37 VSS:21 VSS:15 0.01

*|NET VDD 4.2332e-05PF
*|P (VDD B 0 0.1050 0.1440)
*|I (M5:DRN M5 DRN B 0 0.1740 0.1080)
*|I (M8:SRC M8 SRC B 0 0.0360 0.1080)
C2_1 VDD VSS:10 7.79004e-20
C2_2 VDD:13 VSS:10 3.83957e-20
C2_3 VDD:14 VSS:10 6.70874e-21
C2_4 VDD:17 VSS:10 6.38861e-20
C2_5 VDD VSS:15 1.47837e-18
C2_6 VDD:4 VSS:15 8.02586e-19
C2_7 VDD:17 VSS:15 1.49934e-18
C2_8 VDD VSS:20 9.28714e-19
C2_9 VDD:13 VSS:20 2.76282e-20
C2_10 VDD VSS:21 8.78916e-22
C2_11 VDD:14 VSS:21 3.86285e-21
C2_12 VDD:17 VSS:21 1.20446e-19
Cg2_13 VDD VSS 7.98394e-18
Cg2_14 VDD:4 VSS 2.52098e-19
Cg2_15 VDD:5 VSS 1.78742e-19
Cg2_16 VDD:13 VSS 1.15344e-17
Cg2_17 VDD:14 VSS 5.43919e-21
Cg2_18 VDD:17 VSS 7.87308e-19
R2_1 VDD VDD:7 25.0832
R2_2 VDD VDD:9 63.5281
R2_3 VDD VDD:10 25.0832
R2_4 VDD VDD:15 38473.3
R2_5 M5:DRN VDD:16 30000.0
R2_6 M5:DRN VDD:5 30000.0
R2_7 M5:DRN VDD:22 15000.0
R2_8 M8:SRC VDD:14 30000.0
R2_9 M8:SRC VDD:4 30000.0
R2_10 M8:SRC VDD:20 15000.0
R2_11 VDD:4 VDD:20 7.8411
R2_12 VDD:4 VDD:21 1.77981
R2_13 VDD:5 VDD:22 7.8411
R2_14 VDD:5 VDD:23 1.77981
R2_15 VDD:6 VDD:24 17.9166
R2_16 VDD:6 VDD:7 25.0832
R2_17 VDD:6 VDD:17 31.764
R2_18 VDD:7 VDD:8 63.5281
R2_19 VDD:8 VDD:17 50.1851
R2_20 VDD:8 VDD:9 55.4677
R2_21 VDD:9 VDD:11 55.4677
R2_22 VDD:10 VDD:11 63.5281
R2_23 VDD:10 VDD:12 25.0832
R2_24 VDD:11 VDD:13 50.1851
R2_25 VDD:12 VDD:13 31.764
R2_26 VDD:12 VDD:25 17.9166
R2_27 VDD:13 VDD:16 12.4587
R2_28 VDD:13 VDD:19 34.3372
R2_29 VDD:14 VDD:20 7.8411
R2_30 VDD:14 VDD:17 12.4587
R2_31 VDD:16 VDD:22 7.8411
R2_32 VDD:17 VDD:18 34.3372

*|NET Y 2.96249e-05PF
*|P (Y B 0 0.1890 0.0720)
*|I (M1:DRN M1 DRN B 0 0.1740 0.0360)
*|I (M5:SRC M5 SRC B 0 0.1620 0.1080)
*|I (M6:DRN M6 DRN B 0 0.1320 0.1080)
C3_1 M1:DRN VSS:10 7.34397e-20
C3_2 Y:6 VSS:10 2.43687e-18
C3_3 Y:14 VSS:10 1.03218e-19
C3_4 Y:13 VSS:15 3.31956e-19
C3_5 Y:14 VSS:15 4.68408e-19
C3_6 Y:14 VSS:18 7.77805e-20
C3_7 Y:14 VSS:19 2.34916e-19
C3_8 Y:6 VSS:20 1.39897e-19
C3_9 Y:13 VSS:20 3.05983e-19
C3_10 Y:14 VSS:20 1.46695e-18
C3_11 Y:5 VDD 1.88836e-19
C3_12 Y:13 VDD 4.19807e-18
C3_13 Y:14 VDD 6.64928e-20
C3_14 Y:13 VDD:5 8.99776e-20
C3_15 Y:14 VDD:5 1.53689e-19
C3_16 Y:5 VDD:13 1.19561e-18
C3_17 Y:6 VDD:13 3.71275e-19
C3_18 Y:13 VDD:13 4.23712e-19
C3_19 Y:14 VDD:13 2.02145e-19
C3_20 Y:5 VDD:16 3.62152e-20
C3_21 Y:6 VDD:16 1.99121e-20
C3_22 Y:7 VDD:16 3.01108e-20
C3_23 Y:13 VDD:16 3.99147e-20
C3_24 Y:14 VDD:16 2.28626e-20
Cg3_25 Y:5 VSS 3.17072e-19
Cg3_26 Y:6 VSS 3.10596e-19
Cg3_27 Y:7 VSS 2.31761e-19
Cg3_28 Y:8 VSS 1.78742e-19
Cg3_29 Y:13 VSS 1.2029e-18
Cg3_30 Y:14 VSS 2.61331e-18
R3_1 Y Y:13 25.8596
R3_2 Y Y:11 21.4999
R3_3 M1:DRN Y:8 30000.0
R3_4 M1:DRN Y:6 30000.0
R3_5 M1:DRN Y:12 15000.0
R3_6 M5:SRC Y:5 30000.0
R3_7 M5:SRC Y:15 20089.3
R3_8 M5:SRC Y:7 59210.5
R3_9 M5:SRC Y:10 30000.0
R3_10 M6:DRN Y:5 30000.0
R3_11 M6:DRN Y:15 20089.3
R3_12 M6:DRN Y:7 59210.5
R3_13 M6:DRN Y:10 30000.0
R3_14 Y:5 Y:10 14.1199
R3_15 Y:5 Y:15 8.62446
R3_16 Y:6 Y:12 9.78801
R3_17 Y:7 Y:10 5.45702
R3_18 Y:8 Y:12 9.78801
R3_19 Y:9 Y:10 63.5281
R3_20 Y:9 Y:16 3.58332
R3_21 Y:9 Y:13 25.0832
R3_22 Y:10 Y:15 21900.0
R3_23 Y:11 Y:12 63.5281
R3_24 Y:11 Y:14 7.8833

*|NET A 1.84238e-05PF
*|P (A B 0 0.0210 0.0720)
*|I (M4:GATE M4 GATE I 3.6e-19 0.0420 0.0360)
*|I (M8:GATE M8 GATE I 3.6e-19 0.0420 0.1080)
C4_1 A:10 VSS:5 2.44346e-19
C4_2 A:4 VSS:10 4.61602e-19
C4_3 A:5 VSS:10 7.89427e-21
C4_4 A:10 VSS:10 9.63817e-20
C4_5 A:10 VSS:15 9.56892e-19
C4_6 A:10 VSS:16 4.74872e-20
C4_7 A:4 VSS:20 1.5268e-20
C4_8 A:10 VSS:20 1.47077e-18
C4_9 A:8 VSS:21 9.16124e-19
C4_10 A:10 VSS:21 6.15563e-19
C4_11 A:4 VDD 4.02543e-21
C4_12 A:7 VDD 3.6211e-20
C4_13 A:8 VDD 2.83023e-20
C4_14 A:10 VDD 1.47862e-18
C4_15 A:10 VDD:4 1.1494e-19
C4_16 A:7 VDD:13 1.15802e-19
C4_17 A:8 VDD:14 1.48933e-20
C4_18 A:10 VDD:14 1.18559e-19
C4_19 A:8 VDD:17 1.58128e-18
C4_20 A:10 VDD:17 4.73109e-19
Cg4_21 A:4 VSS 1.09486e-19
Cg4_22 A:6 VSS 3.4119e-19
Cg4_23 A:7 VSS 2.31874e-19
Cg4_24 A:8 VSS 1.99342e-19
Cg4_25 A:10 VSS 3.80457e-18
R4_1 A A:10 29.3832
R4_2 A A:13 29.4429
R4_3 A A:9 63.5281
R4_4 M4:GATE A:5 7.57576
R4_5 M4:GATE A:4 7.57576
R4_6 M8:GATE A:7 13.1313
R4_7 M8:GATE A:6 7.57576
R4_8 A:4 A:11 5.55556
R4_9 A:5 A:8 10.6061
R4_10 A:6 A:8 10.6061
R4_11 A:8 A:9 27.7339
R4_12 A:9 A:12 7.92396

*|NET B 1.85376e-05PF
*|P (B B 0 0.0630 0.0720)
*|I (M3:GATE M3 GATE I 3.6e-19 0.0840 0.0360)
*|I (M7:GATE M7 GATE I 3.6e-19 0.0840 0.1080)
C5_1 B:10 VSS:5 1.53602e-20
C5_2 B:4 VSS:10 5.61697e-19
C5_3 B:5 VSS:10 7.89427e-21
C5_4 B:8 VSS:15 9.19865e-21
C5_5 B:10 VSS:15 3.52889e-19
C5_6 B:4 VSS:20 2.5889e-20
C5_7 B:10 VSS:20 1.63451e-19
C5_8 B:10 VSS:21 3.53609e-20
C5_9 B:7 VDD 1.01895e-19
C5_10 B:8 VDD 4.20689e-20
C5_11 B:10 VDD 1.7053e-18
C5_12 B:10 VDD:4 8.37832e-20
C5_13 B:7 VDD:13 1.16249e-19
C5_14 B:10 VDD:17 1.08178e-19
C5_15 B:10 A:10 3.24445e-18
Cg5_16 B:4 VSS 2.08947e-19
Cg5_17 B:6 VSS 3.4119e-19
Cg5_18 B:7 VSS 1.57023e-19
Cg5_19 B:8 VSS 2.14171e-19
Cg5_20 B:10 VSS 1.88021e-18
R5_1 B B:10 12.8402
R5_2 B B:13 29.4429
R5_3 B B:9 63.5281
R5_4 M3:GATE B:5 7.57576
R5_5 M3:GATE B:4 7.57576
R5_6 M7:GATE B:7 13.1313
R5_7 M7:GATE B:6 7.57576
R5_8 B:4 B:11 5.55556
R5_9 B:5 B:8 10.6061
R5_10 B:6 B:8 10.6061
R5_11 B:8 B:9 27.7339
R5_12 B:9 B:12 7.92396

*|NET C 1.87343e-05PF
*|P (C B 0 0.1050 0.0720)
*|I (M2:GATE M2 GATE I 3.6e-19 0.1260 0.0360)
*|I (M6:GATE M6 GATE I 3.6e-19 0.1260 0.1080)
C6_1 C:5 VSS:6 1.22766e-18
C6_2 C:4 VSS:10 4.59524e-19
C6_3 C:5 VSS:10 6.95141e-19
C6_4 C:6 VSS:10 1.83918e-19
C6_5 C:8 VSS:10 9.81086e-19
C6_6 C:10 VSS:10 4.03869e-19
C6_7 C:8 VSS:15 8.65298e-21
C6_8 C:10 VSS:15 2.5394e-19
C6_9 C:4 VSS:20 2.98805e-20
C6_10 C:10 VSS:20 1.35933e-19
C6_11 C:7 VDD 1.05037e-19
C6_12 C:8 VDD 4.20689e-20
C6_13 C:10 VDD 1.62861e-18
C6_14 C:7 VDD:13 1.16249e-19
C6_15 C:4 M1:DRN 1.7219e-20
C6_16 C:10 Y:13 9.07746e-19
C6_17 C:4 Y:14 6.35299e-21
C6_18 C:10 Y:14 4.09494e-19
C6_19 C:4 B:4 3.12363e-20
C6_20 C:10 B:5 2.44421e-20
C6_21 C:10 B:6 1.79588e-19
C6_22 C:10 B:10 3.13617e-18
Cg6_23 C:4 VSS 2.17803e-19
Cg6_24 C:6 VSS 3.4119e-19
Cg6_25 C:7 VSS 1.57023e-19
Cg6_26 C:8 VSS 2.14171e-19
Cg6_27 C:10 VSS 1.80485e-18
R6_1 C C:10 12.8402
R6_2 C C:13 29.4429
R6_3 C C:9 63.5281
R6_4 M2:GATE C:5 7.57576
R6_5 M2:GATE C:4 7.57576
R6_6 M6:GATE C:7 13.1313
R6_7 M6:GATE C:6 7.57576
R6_8 C:4 C:11 5.55556
R6_9 C:5 C:8 10.6061
R6_10 C:6 C:8 10.6061
R6_11 C:8 C:9 27.7339
R6_12 C:9 C:12 7.92396

*|NET D 2.14836e-05PF
*|P (D B 0 0.1470 0.0720)
*|I (M1:GATE M1 GATE I 3.6e-19 0.1680 0.0360)
*|I (M5:GATE M5 GATE I 3.6e-19 0.1680 0.1080)
C7_1 D:11 VSS:6 1.53602e-20
C7_2 D:4 VSS:10 4.61602e-19
C7_3 D:5 VSS:10 7.89427e-21
C7_4 D:11 VSS:10 3.53609e-20
C7_5 D:11 VSS:15 1.80512e-19
C7_6 D:4 VSS:20 4.06443e-20
C7_7 D:11 VSS:20 1.62085e-19
C7_8 D:9 M6:DRN 1.65859e-20
C7_9 D:6 Y:5 1.83918e-19
C7_10 D:7 Y:5 6.85454e-19
C7_11 D:8 Y:5 1.82222e-19
C7_12 D:9 Y:5 1.6205e-18
C7_13 D:11 Y:5 1.03961e-19
C7_14 D:7 Y:7 1.22802e-18
C7_15 D:6 Y:13 1.24019e-19
C7_16 D:7 Y:13 7.29345e-20
C7_17 D:8 Y:13 3.14075e-20
C7_18 D:9 Y:13 1.24808e-19
C7_19 D:11 Y:13 1.60733e-18
C7_20 D:5 Y:14 1.64252e-19
C7_21 D:6 Y:14 2.18239e-19
C7_22 D:7 Y:14 8.90117e-20
C7_23 D:9 Y:14 2.90465e-19
C7_24 D:11 Y:14 2.04754e-18
C7_25 D:4 C:4 5.04585e-19
C7_26 D:11 C:5 2.44421e-20
C7_27 D:11 C:6 1.83969e-19
C7_28 D:11 C:10 1.97437e-18
Cg7_29 D:4 VSS 1.00945e-19
Cg7_30 D:6 VSS 9.8281e-19
Cg7_31 D:8 VSS 4.29622e-19
Cg7_32 D:9 VSS 4.49724e-19
Cg7_33 D:11 VSS 1.26799e-18
R7_1 D D:11 12.8402
R7_2 D D:14 12.8402
R7_3 D D:10 63.5281
R7_4 M1:GATE D:5 7.57576
R7_5 M1:GATE D:4 7.57576
R7_6 M5:GATE D:7 7.57576
R7_7 M5:GATE D:6 7.57576
R7_8 D:4 D:12 5.55556
R7_9 D:5 D:9 10.6061
R7_10 D:6 D:9 10.6061
R7_11 D:7 D:8 5.55556
R7_12 D:9 D:10 27.7339
R7_13 D:10 D:13 7.92396

*|NET 12 5.71731e-07PF
*|I (M7:SRC M7 SRC B 0 0.0780 0.1080)
*|I (M8:DRN M8 DRN B 0 0.0480 0.1080)
C9_1 M8:DRN VDD 5.48958e-20
C9_2 M8:DRN VDD:4 2.82443e-20
C9_3 M8:DRN VDD:17 2.13821e-20
C9_4 M8:DRN B:8 3.20941e-19
C9_5 M8:DRN B:10 1.06636e-19
R9_1 M7:SRC M8:DRN 15000.0

*|NET 13 5.60394e-07PF
*|I (M6:SRC M6 SRC B 0 0.1200 0.1080)
*|I (M7:DRN M7 DRN B 0 0.0900 0.1080)
C10_1 M7:DRN VSS:10 4.14942e-20
C10_2 M7:DRN VDD 9.32879e-20
C10_3 M7:DRN C:8 3.20941e-19
C10_4 M7:DRN C:10 1.04671e-19
R10_1 M6:SRC M7:DRN 15000.0

*|NET 4 3.24699e-05PF
*|I (M1:SRC M1 SRC B 0 0.1620 0.0360)
*|I (M2:DRN M2 DRN B 0 0.1320 0.0360)
*|I (M3:SRC M3 SRC B 0 0.0780 0.0360)
*|I (M4:DRN M4 DRN B 0 0.0480 0.0360)
C11_1 M4:DRN VSS:5 2.82443e-20
C11_2 4:13 VSS:5 6.05689e-20
C11_3 M2:DRN VSS:6 3.00786e-20
C11_4 4:13 VSS:6 1.50542e-19
C11_5 M2:DRN VSS:10 4.56638e-20
C11_6 M4:DRN VSS:10 2.09115e-20
C11_7 4:5 VSS:10 2.32373e-18
C11_8 4:6 VSS:10 2.32373e-18
C11_9 4:13 VSS:10 1.03209e-18
C11_10 4:5 VSS:15 7.88711e-21
C11_11 4:13 VSS:15 3.09656e-19
C11_12 4:5 VSS:17 3.04542e-20
C11_13 4:7 VSS:17 3.00786e-20
C11_14 4:13 VSS:17 5.43868e-20
C11_15 4:5 VSS:18 1.80459e-19
C11_16 4:13 VSS:18 1.16426e-19
C11_17 4:5 VSS:20 7.29082e-20
C11_18 4:6 VSS:20 9.63358e-20
C11_19 4:13 VSS:20 7.05327e-18
C11_20 M4:DRN VSS:21 2.13821e-20
C11_21 4:13 VSS:21 6.53731e-20
C11_22 4:6 M1:DRN 3.61561e-20
C11_23 4:8 M1:DRN 3.00786e-20
C11_24 4:6 M6:DRN 3.52036e-21
C11_25 4:6 Y:5 1.27884e-19
C11_26 4:13 Y:13 1.16433e-19
C11_27 4:6 Y:14 1.39813e-19
C11_28 4:8 Y:14 1.01519e-19
C11_29 4:13 Y:14 9.69675e-19
C11_30 4:13 A:10 1.07286e-18
C11_31 4:13 B:4 9.41789e-21
C11_32 4:5 B:5 6.88428e-19
C11_33 4:7 B:5 1.23066e-18
C11_34 4:13 B:5 7.12623e-20
C11_35 4:5 B:6 1.83918e-19
C11_36 4:13 B:6 1.24019e-19
C11_37 4:5 B:8 9.63688e-19
C11_38 4:5 B:10 3.95506e-19
C11_39 4:13 B:10 1.69649e-18
C11_40 4:13 C:4 6.13456e-21
C11_41 4:13 C:5 7.94481e-20
C11_42 4:13 C:6 1.24019e-19
C11_43 4:5 C:10 3.53609e-20
C11_44 4:7 C:10 1.53602e-20
C11_45 4:13 C:10 1.64215e-18
C11_46 4:6 D:4 1.83918e-19
C11_47 4:6 D:5 6.89422e-19
C11_48 4:8 D:5 1.24376e-18
C11_49 4:13 D:5 7.69091e-20
C11_50 4:6 D:6 1.83918e-19
C11_51 4:6 D:9 9.60833e-19
C11_52 4:6 D:11 3.89081e-19
C11_53 4:13 D:11 1.61432e-18
C11_54 4:5 M8:DRN 3.96311e-20
Cg11_55 4:5 VSS 3.49362e-19
Cg11_56 4:6 VSS 3.48101e-19
Cg11_57 4:7 VSS 2.55731e-19
Cg11_58 4:8 VSS 2.40359e-19
Cg11_59 4:13 VSS 1.97661e-18
R11_1 M1:SRC 4:8 30000.0
R11_2 M1:SRC 4:15 20270.3
R11_3 M1:SRC 4:6 57692.3
R11_4 M1:SRC 4:12 30000.0
R11_5 M2:DRN 4:8 30000.0
R11_6 M2:DRN 4:15 20270.3
R11_7 M2:DRN 4:6 57692.3
R11_8 M2:DRN 4:12 30000.0
R11_9 M3:SRC 4:7 30000.0
R11_10 M3:SRC 4:14 20270.3
R11_11 M3:SRC 4:5 57692.3
R11_12 M3:SRC 4:10 30000.0
R11_13 M4:DRN 4:7 30000.0
R11_14 M4:DRN 4:14 20270.3
R11_15 M4:DRN 4:5 57692.3
R11_16 M4:DRN 4:10 30000.0
R11_17 4:5 4:10 5.51634
R11_18 4:6 4:12 5.51634
R11_19 4:7 4:10 14.0605
R11_20 4:7 4:14 49500.0
R11_21 4:8 4:12 14.0605
R11_22 4:8 4:15 49500.0
R11_23 4:9 4:10 63.5281
R11_24 4:9 4:13 3.58332
R11_25 4:9 4:11 50.1665
R11_26 4:10 4:14 3.7634
R11_27 4:11 4:12 63.5281
R11_28 4:11 4:16 3.58332
R11_29 4:12 4:15 3.7634

*|NET _generated_14 2.86348e-06PF
C12_1 _generated_14:1 VSS:15 6.61239e-19
C12_2 _generated_14:1 VSS:20 2.25577e-20
C12_3 _generated_14:1 VSS:21 3.44976e-19
C12_4 _generated_14:1 A:10 3.06042e-19
Cg12_5 _generated_14:1 VSS 9.49624e-19
R12_1 _generated_14:1 _generated_14:2 28.2828

*|NET _generated_15 3.08088e-06PF
C13_1 _generated_15:1 VSS:10 1.47021e-19
C13_2 _generated_15:1 VSS:15 5.65589e-19
C13_3 _generated_15:1 VDD 4.89892e-20
C13_4 _generated_15:1 VDD:13 1.18927e-19
C13_5 _generated_15:1 VDD:17 3.74453e-19
C13_6 _generated_15:1 A:10 3.15962e-19
C13_7 _generated_15:1 _generated_14:1 5.79044e-19
Cg13_8 _generated_15:1 VSS 9.3089e-19
R13_1 _generated_15:1 _generated_15:2 28.2828

*|NET _generated_16 5.30834e-06PF
C14_1 _generated_16:1 VSS:10 4.70573e-19
C14_2 _generated_16:1 VSS:15 2.98844e-20
C14_3 _generated_16:1 VSS:20 7.3476e-20
C14_4 _generated_16:1 Y:6 3.81915e-19
C14_5 _generated_16:1 Y:14 5.37388e-20
C14_6 _generated_16:1 D:4 4.75026e-20
C14_7 _generated_16:1 D:6 2.39886e-19
Cg14_8 _generated_16:1 VSS 3.40722e-18
R14_1 _generated_16:1 _generated_16:2 28.2828

*|NET _generated_17 4.9736e-06PF
C15_1 _generated_17:1 VDD 1.68485e-19
C15_2 _generated_17:1 VDD:13 5.78695e-19
C15_3 _generated_17:1 D:6 2.39886e-19
C15_4 _generated_17:1 D:8 1.58022e-21
C15_5 _generated_17:1 _generated_16:1 6.0415e-19
Cg15_6 _generated_17:1 VSS 3.3808e-18
R15_1 _generated_17:1 _generated_17:2 28.2828

*
* Instance Section
*
MM1 M1:DRN M1:GATE M1:SRC VSS NMOS_LVT l=0.012u w=0.03u NF=1
MM2 M2:DRN M2:GATE M2:SRC VSS NMOS_LVT l=0.012u w=0.03u NF=1
MM3 M3:DRN M3:GATE M3:SRC VSS NMOS_LVT l=0.012u w=0.03u NF=1
MM4 M4:DRN M4:GATE M4:SRC VSS NMOS_LVT l=0.012u w=0.03u NF=1
MM5 M5:DRN M5:GATE M5:SRC VDD PMOS_LVT l=0.012u w=0.03u NF=1
MM6 M6:DRN M6:GATE M6:SRC VDD PMOS_LVT l=0.012u w=0.03u NF=1
MM7 M7:DRN M7:GATE M7:SRC VDD PMOS_LVT l=0.012u w=0.03u NF=1
MM8 M8:DRN M8:GATE M8:SRC VDD PMOS_LVT l=0.012u w=0.03u NF=1

.ENDS
