*
*|DSPF 1.3
*|DESIGN NOR4x1
*|DATE "Tue Nov  3 20:53:40 2026"
*|VENDOR "Synopsys"
*|PROGRAM "StarRC"
*|VERSION "X-2025.06-SP1"
*|DIVIDER /
*|DELIMITER :
**FORMAT SPF
*

** COMMENTS

** OPERATING_TEMPERATURE 25
** GLOBAL_TEMPERATURE 25
**
** TCAD_GRD_FILE /cedar/cedar_coe/ece-limsk/yhuang861/GRO/.planning/experiments_migrated_20261022/usc144_github_release_20261103/sources/github_FSPR.nxtgrd
**   TCAD_TIME_STAMP Tue Mar 31 05:07:55 2026
**   TCADGRD_VERSION 89

.SUBCKT NOR4x1 VSS VDD Y A B C D

*|GROUND_NET VSS

*|NET VSS 8.45334e-05PF
*|P (VSS B 0 0.1050 0.0000)
*|I (M1:DRN M1 DRN B 0 0.1740 0.0360)
*|I (M2:SRC M2 SRC B 0 0.1200 0.0360)
*|I (M3:DRN M3 DRN B 0 0.0900 0.0360)
*|I (M4:SRC M4 SRC B 0 0.0360 0.0360)
Cg1_1 VSS:6 VSS 2.60582e-19
Cg1_2 VSS:7 VSS 2.65379e-19
Cg1_3 VSS:8 VSS 1.78742e-19
Cg1_4 VSS:15 VSS 2.61369e-18
Cg1_5 VSS:16 VSS 2.98124e-17
Cg1_6 VSS:20 VSS 4.59594e-18
Cg1_7 VSS:22 VSS 6.90979e-18
Cg1_8 VSS:23 VSS 7.07112e-19
Cg1_9 VSS:24 VSS 5.32932e-19
R1_1 VSS VSS:10 25.0832
R1_2 VSS VSS:12 25.0832
R1_3 VSS VSS:23 31.764
R1_4 M1:DRN VSS:19 30000.0
R1_5 M1:DRN VSS:8 30000.0
R1_6 M1:DRN VSS:31 15000.0
R1_7 M2:SRC VSS:18 30000.0
R1_8 M2:SRC VSS:7 30000.0
R1_9 M2:SRC VSS:29 15000.0
R1_10 M3:DRN VSS:18 30000.0
R1_11 M3:DRN VSS:7 30000.0
R1_12 M3:DRN VSS:29 15000.0
R1_13 M4:SRC VSS:17 30000.0
R1_14 M4:SRC VSS:6 30000.0
R1_15 M4:SRC VSS:27 15000.0
R1_16 VSS:6 VSS:27 7.8411
R1_17 VSS:6 VSS:24 12.4587
R1_18 VSS:7 VSS:29 7.84041
R1_19 VSS:7 VSS:23 12.4587
R1_20 VSS:8 VSS:31 7.8411
R1_21 VSS:8 VSS:15 12.4587
R1_22 VSS:9 VSS:22 17.9166
R1_23 VSS:9 VSS:10 25.0832
R1_24 VSS:9 VSS:24 31.764
R1_25 VSS:10 VSS:11 63.5281
R1_26 VSS:11 VSS:24 50.1851
R1_27 VSS:11 VSS:23 50.1851
R1_28 VSS:12 VSS:13 63.5281
R1_29 VSS:12 VSS:14 25.0832
R1_30 VSS:13 VSS:23 50.1851
R1_31 VSS:13 VSS:15 50.1851
R1_32 VSS:14 VSS:15 31.764
R1_33 VSS:14 VSS:33 17.9166
R1_34 VSS:15 VSS:26 34.3372
R1_35 VSS:16 VSS:20 7778.54
R1_36 VSS:17 VSS:27 7.8411
R1_37 VSS:17 VSS:28 1.77981
R1_38 VSS:18 VSS:29 7.84041
R1_39 VSS:18 VSS:30 1.77981
R1_40 VSS:19 VSS:31 7.8411
R1_41 VSS:19 VSS:32 1.77981
R1_42 VSS:20 VSS:21 2423.78
R1_43 VSS:24 VSS:25 34.3372
R1_44 VSS:24 VSS:16 0.01

*|NET VDD 3.81777e-05PF
*|P (VDD B 0 0.1050 0.1440)
*|I (M8:SRC M8 SRC B 0 0.0360 0.1080)
C2_1 VDD VSS:15 7.79004e-20
C2_2 VDD:5 VSS:15 1.02282e-19
C2_3 VDD:13 VSS:15 6.70874e-21
C2_4 VDD VSS:16 1.31719e-18
C2_5 VDD:3 VSS:16 8.02586e-19
C2_6 VDD:5 VSS:16 1.49934e-18
C2_7 VDD VSS:22 9.48429e-19
C2_8 VDD:5 VSS:22 2.76282e-20
C2_9 VDD VSS:24 8.78916e-22
C2_10 VDD:5 VSS:24 1.20446e-19
C2_11 VDD:13 VSS:24 3.86285e-21
Cg2_12 VDD VSS 6.98344e-18
Cg2_13 VDD:3 VSS 2.52098e-19
Cg2_14 VDD:5 VSS 1.12537e-17
Cg2_15 VDD:13 VSS 5.43919e-21
R2_1 VDD VDD:6 25.0832
R2_2 VDD VDD:8 63.5281
R2_3 VDD VDD:9 25.0832
R2_4 VDD VDD:14 38473.3
R2_5 M8:SRC VDD:13 30000.0
R2_6 M8:SRC VDD:3 30000.0
R2_7 M8:SRC VDD:17 15000.0
R2_8 VDD:3 VDD:17 7.8411
R2_9 VDD:3 VDD:18 1.77981
R2_10 VDD:4 VDD:5 31.764
R2_11 VDD:4 VDD:19 17.9166
R2_12 VDD:4 VDD:6 25.0832
R2_13 VDD:5 VDD:7 50.1851
R2_14 VDD:5 VDD:13 12.4587
R2_15 VDD:5 VDD:15 34.3372
R2_16 VDD:6 VDD:7 63.5281
R2_17 VDD:7 VDD:8 55.4677
R2_18 VDD:8 VDD:10 55.4677
R2_19 VDD:9 VDD:10 63.5281
R2_20 VDD:9 VDD:11 25.0832
R2_21 VDD:10 VDD:12 55.4677
R2_22 VDD:11 VDD:12 63.5281
R2_23 VDD:11 VDD:20 17.9166
R2_24 VDD:12 VDD:16 39.6198
R2_25 VDD:13 VDD:17 7.8411

*|NET Y 4.79496e-05PF
*|P (Y B 0 0.1890 0.0720)
*|I (M1:SRC M1 SRC B 0 0.1620 0.0360)
*|I (M2:DRN M2 DRN B 0 0.1320 0.0360)
*|I (M3:SRC M3 SRC B 0 0.0780 0.0360)
*|I (M4:DRN M4 DRN B 0 0.0480 0.0360)
*|I (M5:DRN M5 DRN B 0 0.1740 0.1080)
C3_1 M4:DRN VSS:6 2.82443e-20
C3_2 Y:19 VSS:6 6.05689e-20
C3_3 M2:DRN VSS:7 3.00786e-20
C3_4 Y:19 VSS:7 1.94772e-19
C3_5 Y:19 VSS:8 1.32169e-19
C3_6 Y:20 VSS:8 1.59634e-19
C3_7 M2:DRN VSS:15 2.08949e-20
C3_8 M4:DRN VSS:15 2.09115e-20
C3_9 M5:DRN VSS:15 1.79419e-20
C3_10 Y:7 VSS:15 2.32373e-18
C3_11 Y:8 VSS:15 2.31904e-18
C3_12 Y:9 VSS:15 3.79104e-19
C3_13 Y:19 VSS:15 7.12393e-19
C3_14 Y:20 VSS:15 5.69137e-19
C3_15 Y:7 VSS:16 7.88711e-21
C3_16 Y:8 VSS:16 2.18521e-21
C3_17 Y:19 VSS:16 3.84e-19
C3_18 Y:20 VSS:16 5.91503e-19
C3_19 Y:7 VSS:18 3.04542e-20
C3_20 Y:10 VSS:18 3.00786e-20
C3_21 Y:19 VSS:18 5.43868e-20
C3_22 Y:8 VSS:19 3.61561e-20
C3_23 Y:11 VSS:19 3.00786e-20
C3_24 Y:19 VSS:19 3.93791e-20
C3_25 Y:20 VSS:19 2.27223e-20
C3_26 Y:7 VSS:20 1.80439e-19
C3_27 Y:19 VSS:20 2.00835e-19
C3_28 Y:19 VSS:21 1.03136e-19
C3_29 Y:20 VSS:21 9.82829e-20
C3_30 Y:7 VSS:22 1.62956e-19
C3_31 Y:8 VSS:22 1.31554e-19
C3_32 Y:19 VSS:22 9.70197e-18
C3_33 Y:20 VSS:22 1.00178e-19
C3_34 M2:DRN VSS:23 2.47523e-20
C3_35 Y:19 VSS:23 4.79944e-19
C3_36 M4:DRN VSS:24 2.13821e-20
C3_37 Y:19 VSS:24 6.53731e-20
C3_38 Y:9 VDD 1.73053e-19
C3_39 Y:19 VDD 8.82972e-19
C3_40 Y:20 VDD 1.55723e-18
C3_41 Y:9 VDD:5 1.05946e-18
Cg3_42 Y:7 VSS 3.49389e-19
Cg3_43 Y:8 VSS 3.38357e-19
Cg3_44 Y:9 VSS 2.8933e-19
Cg3_45 Y:10 VSS 2.55731e-19
Cg3_46 Y:11 VSS 2.31922e-19
Cg3_47 Y:12 VSS 1.78742e-19
Cg3_48 Y:19 VSS 1.97647e-18
Cg3_49 Y:20 VSS 2.60227e-18
R3_1 Y Y:17 21.4999
R3_2 Y Y:19 25.7999
R3_3 M1:SRC Y:11 30000.0
R3_4 M1:SRC Y:22 20270.3
R3_5 M1:SRC Y:8 57692.3
R3_6 M1:SRC Y:16 30000.0
R3_7 M2:DRN Y:11 30000.0
R3_8 M2:DRN Y:22 20270.3
R3_9 M2:DRN Y:8 57692.3
R3_10 M2:DRN Y:16 30000.0
R3_11 M3:SRC Y:10 30000.0
R3_12 M3:SRC Y:21 20270.3
R3_13 M3:SRC Y:7 57692.3
R3_14 M3:SRC Y:14 30000.0
R3_15 M4:DRN Y:10 30000.0
R3_16 M4:DRN Y:21 20270.3
R3_17 M4:DRN Y:7 57692.3
R3_18 M4:DRN Y:14 30000.0
R3_19 M5:DRN Y:12 30000.0
R3_20 M5:DRN Y:9 30000.0
R3_21 M5:DRN Y:18 15000.0
R3_22 Y:7 Y:14 5.51634
R3_23 Y:8 Y:16 5.51634
R3_24 Y:9 Y:18 9.78801
R3_25 Y:10 Y:14 14.0605
R3_26 Y:10 Y:21 49500.0
R3_27 Y:11 Y:16 14.0605
R3_28 Y:11 Y:22 49500.0
R3_29 Y:12 Y:18 9.78801
R3_30 Y:13 Y:14 63.5281
R3_31 Y:13 Y:23 3.58332
R3_32 Y:13 Y:15 50.1665
R3_33 Y:14 Y:21 3.7634
R3_34 Y:15 Y:16 63.5281
R3_35 Y:15 Y:19 25.0832
R3_36 Y:16 Y:22 3.7634
R3_37 Y:17 Y:18 63.5281
R3_38 Y:17 Y:20 7.94303

*|NET A 1.83815e-05PF
*|P (A B 0 0.0210 0.0720)
*|I (M4:GATE M4 GATE I 3.6e-19 0.0420 0.0360)
*|I (M8:GATE M8 GATE I 3.6e-19 0.0420 0.1080)
C4_1 A:10 VSS:6 2.44346e-19
C4_2 A:4 VSS:15 4.61602e-19
C4_3 A:5 VSS:15 7.89427e-21
C4_4 A:10 VSS:15 9.63817e-20
C4_5 A:10 VSS:16 9.56892e-19
C4_6 A:10 VSS:17 4.74872e-20
C4_7 A:4 VSS:22 2.75992e-20
C4_8 A:10 VSS:22 1.48353e-18
C4_9 A:8 VSS:24 9.16124e-19
C4_10 A:10 VSS:24 6.15563e-19
C4_11 A:4 VDD 4.02543e-21
C4_12 A:7 VDD 4.85422e-20
C4_13 A:8 VDD 2.83023e-20
C4_14 A:10 VDD 1.49137e-18
C4_15 A:10 VDD:3 1.1494e-19
C4_16 A:7 VDD:5 1.15802e-19
C4_17 A:8 VDD:5 1.58128e-18
C4_18 A:10 VDD:5 4.73109e-19
C4_19 A:8 VDD:13 1.48933e-20
C4_20 A:10 VDD:13 1.18559e-19
C4_21 A:10 Y:19 9.49071e-19
C4_22 A:10 Y:20 8.35009e-20
Cg4_23 A:4 VSS 1.09486e-19
Cg4_24 A:6 VSS 3.4119e-19
Cg4_25 A:7 VSS 2.31874e-19
Cg4_26 A:8 VSS 1.99342e-19
Cg4_27 A:10 VSS 3.75236e-18
R4_1 A A:10 29.3832
R4_2 A A:13 29.4429
R4_3 A A:9 63.5281
R4_4 M4:GATE A:5 7.57576
R4_5 M4:GATE A:4 7.57576
R4_6 M8:GATE A:7 13.1313
R4_7 M8:GATE A:6 7.57576
R4_8 A:4 A:11 5.55556
R4_9 A:5 A:8 10.6061
R4_10 A:6 A:8 10.6061
R4_11 A:8 A:9 27.7339
R4_12 A:9 A:12 7.92396

*|NET B 1.8463e-05PF
*|P (B B 0 0.0630 0.0720)
*|I (M3:GATE M3 GATE I 3.6e-19 0.0840 0.0360)
*|I (M7:GATE M7 GATE I 3.6e-19 0.0840 0.1080)
C5_1 B:10 VSS:6 1.53602e-20
C5_2 B:4 VSS:15 4.59524e-19
C5_3 B:5 VSS:15 7.89427e-21
C5_4 B:8 VSS:16 9.19865e-21
C5_5 B:10 VSS:16 3.52889e-19
C5_6 B:4 VSS:22 4.92456e-20
C5_7 B:10 VSS:22 1.20515e-19
C5_8 B:4 VSS:23 1.02173e-19
C5_9 B:10 VSS:24 3.53609e-20
C5_10 B:7 VDD 1.53746e-19
C5_11 B:8 VDD 4.20689e-20
C5_12 B:10 VDD 1.58564e-18
C5_13 B:10 VDD:3 8.37832e-20
C5_14 B:7 VDD:5 1.16249e-19
C5_15 B:10 VDD:5 1.08178e-19
C5_16 B:5 Y:7 6.88428e-19
C5_17 B:6 Y:7 1.83918e-19
C5_18 B:8 Y:7 9.63688e-19
C5_19 B:10 Y:7 3.95506e-19
C5_20 B:5 Y:10 1.23066e-18
C5_21 B:4 Y:19 9.41789e-21
C5_22 B:5 Y:19 4.77283e-20
C5_23 B:6 Y:19 1.24019e-19
C5_24 B:10 Y:19 1.69649e-18
C5_25 B:10 A:10 3.24445e-18
Cg5_26 B:4 VSS 2.08947e-19
Cg5_27 B:6 VSS 3.4119e-19
Cg5_28 B:7 VSS 1.57023e-19
Cg5_29 B:8 VSS 2.14171e-19
Cg5_30 B:10 VSS 1.92422e-18
R5_1 B B:10 12.8402
R5_2 B B:13 29.4429
R5_3 B B:9 63.5281
R5_4 M3:GATE B:5 7.57576
R5_5 M3:GATE B:4 7.57576
R5_6 M7:GATE B:7 13.1313
R5_7 M7:GATE B:6 7.57576
R5_8 B:4 B:11 5.55556
R5_9 B:5 B:8 10.6061
R5_10 B:6 B:8 10.6061
R5_11 B:8 B:9 27.7339
R5_12 B:9 B:12 7.92396

*|NET C 1.84642e-05PF
*|P (C B 0 0.1050 0.0720)
*|I (M2:GATE M2 GATE I 3.6e-19 0.1260 0.0360)
*|I (M6:GATE M6 GATE I 3.6e-19 0.1260 0.1080)
C6_1 C:5 VSS:7 1.22766e-18
C6_2 C:4 VSS:15 4.60197e-19
C6_3 C:5 VSS:15 7.3486e-21
C6_4 C:8 VSS:16 9.19865e-21
C6_5 C:10 VSS:16 2.57957e-19
C6_6 C:4 VSS:22 2.84649e-20
C6_7 C:10 VSS:22 1.54669e-19
C6_8 C:5 VSS:23 6.88428e-19
C6_9 C:6 VSS:23 1.83918e-19
C6_10 C:8 VSS:23 9.81086e-19
C6_11 C:10 VSS:23 4.03869e-19
C6_12 C:7 VDD 1.01895e-19
C6_13 C:8 VDD 4.20689e-20
C6_14 C:10 VDD 1.68083e-18
C6_15 C:7 VDD:5 1.16249e-19
C6_16 C:10 Y:7 3.53609e-20
C6_17 C:10 Y:10 1.53602e-20
C6_18 C:5 Y:19 7.12623e-20
C6_19 C:6 Y:19 1.24019e-19
C6_20 C:10 Y:19 1.68225e-18
C6_21 C:10 Y:20 3.46579e-19
C6_22 C:4 B:4 3.12363e-20
C6_23 C:10 B:5 2.44421e-20
C6_24 C:10 B:6 1.79588e-19
C6_25 C:10 B:10 3.12845e-18
Cg6_26 C:4 VSS 1.00471e-19
Cg6_27 C:6 VSS 3.4119e-19
Cg6_28 C:7 VSS 1.57023e-19
Cg6_29 C:8 VSS 2.14171e-19
Cg6_30 C:10 VSS 1.86387e-18
R6_1 C C:10 12.8402
R6_2 C C:13 29.4429
R6_3 C C:9 63.5281
R6_4 M2:GATE C:5 7.57576
R6_5 M2:GATE C:4 7.57576
R6_6 M6:GATE C:7 13.1313
R6_7 M6:GATE C:6 7.57576
R6_8 C:4 C:11 5.55556
R6_9 C:5 C:8 10.6061
R6_10 C:6 C:8 10.6061
R6_11 C:8 C:9 27.7339
R6_12 C:9 C:12 7.92396

*|NET D 2.0219e-05PF
*|P (D B 0 0.1470 0.0720)
*|I (M1:GATE M1 GATE I 3.6e-19 0.1680 0.0360)
*|I (M5:GATE M5 GATE I 3.6e-19 0.1680 0.1080)
C7_1 D:11 VSS:7 1.53602e-20
C7_2 D:4 VSS:15 4.68614e-19
C7_3 D:5 VSS:15 7.89427e-21
C7_4 D:9 VSS:16 9.19865e-21
C7_5 D:11 VSS:16 2.32457e-19
C7_6 D:4 VSS:22 2.69506e-20
C7_7 D:11 VSS:22 1.31444e-19
C7_8 D:4 VSS:23 1.10905e-19
C7_9 D:11 VSS:23 3.53609e-20
C7_10 D:8 VDD 1.17249e-19
C7_11 D:9 VDD 4.20689e-20
C7_12 D:11 VDD 1.6161e-18
C7_13 D:8 VDD:5 1.16249e-19
C7_14 D:4 Y:8 1.82222e-19
C7_15 D:5 Y:8 6.85438e-19
C7_16 D:6 Y:8 1.83918e-19
C7_17 D:9 Y:8 9.63688e-19
C7_18 D:11 Y:8 3.95506e-19
C7_19 D:5 Y:11 1.22488e-18
C7_20 D:5 Y:19 7.9414e-20
C7_21 D:6 Y:19 1.24019e-19
C7_22 D:11 Y:19 1.63216e-18
C7_23 D:5 Y:20 1.00427e-19
C7_24 D:6 Y:20 2.24305e-19
C7_25 D:7 Y:20 1.47986e-19
C7_26 D:9 Y:20 2.90465e-19
C7_27 D:11 Y:20 3.18434e-18
C7_28 D:4 C:4 4.50387e-20
C7_29 D:11 C:5 2.44421e-20
C7_30 D:11 C:6 1.79588e-19
C7_31 D:11 C:10 3.12845e-18
Cg7_32 D:4 VSS 9.99012e-20
Cg7_33 D:6 VSS 9.8281e-19
Cg7_34 D:8 VSS 1.68609e-19
Cg7_35 D:9 VSS 4.89595e-19
Cg7_36 D:11 VSS 1.75066e-18
R7_1 D D:11 12.8402
R7_2 D D:14 29.4429
R7_3 D D:10 63.5281
R7_4 M1:GATE D:5 7.57576
R7_5 M1:GATE D:4 7.57576
R7_6 M5:GATE D:7 7.57576
R7_7 M5:GATE D:6 7.57576
R7_8 D:4 D:12 5.55556
R7_9 D:5 D:9 10.6061
R7_10 D:6 D:9 10.6061
R7_11 D:7 D:8 5.55556
R7_12 D:9 D:10 27.7339
R7_13 D:10 D:13 7.92396

*|NET 11 6.37014e-07PF
*|I (M7:SRC M7 SRC B 0 0.0780 0.1080)
*|I (M8:DRN M8 DRN B 0 0.0480 0.1080)
C9_1 M8:DRN VDD 1.20179e-19
C9_2 M8:DRN VDD:3 2.82443e-20
C9_3 M8:DRN VDD:5 2.13821e-20
C9_4 M8:DRN Y:7 3.96311e-20
C9_5 M8:DRN B:8 3.20941e-19
C9_6 M8:DRN B:10 1.06636e-19
R9_1 M7:SRC M8:DRN 15000.0

*|NET 12 5.35964e-07PF
*|I (M6:SRC M6 SRC B 0 0.1200 0.1080)
*|I (M7:DRN M7 DRN B 0 0.0900 0.1080)
C10_1 M7:DRN VSS:23 4.14942e-20
C10_2 M7:DRN VDD 6.68918e-20
C10_3 M7:DRN C:8 3.20941e-19
C10_4 M7:DRN C:10 1.06636e-19
R10_1 M6:SRC M7:DRN 15000.0

*|NET 13 6.11714e-07PF
*|I (M5:SRC M5 SRC B 0 0.1620 0.1080)
*|I (M6:DRN M6 DRN B 0 0.1320 0.1080)
C11_1 M6:DRN VDD 9.9612e-20
C11_2 M6:DRN Y:8 3.96311e-20
C11_3 M6:DRN D:9 3.20941e-19
C11_4 M6:DRN D:11 1.5153e-19
R11_1 M5:SRC M6:DRN 15000.0

*|NET _generated_14 2.86348e-06PF
C12_1 _generated_14:1 VSS:16 6.61239e-19
C12_2 _generated_14:1 VSS:22 2.25577e-20
C12_3 _generated_14:1 VSS:24 3.44976e-19
C12_4 _generated_14:1 A:10 3.06042e-19
Cg12_5 _generated_14:1 VSS 9.49624e-19
R12_1 _generated_14:1 _generated_14:2 28.2828

*|NET _generated_15 3.08088e-06PF
C13_1 _generated_15:1 VSS:15 1.47021e-19
C13_2 _generated_15:1 VSS:16 5.65589e-19
C13_3 _generated_15:1 VDD 4.89892e-20
C13_4 _generated_15:1 VDD:5 4.93381e-19
C13_5 _generated_15:1 A:10 3.15962e-19
C13_6 _generated_15:1 _generated_14:1 5.79044e-19
Cg13_7 _generated_15:1 VSS 9.3089e-19
R13_1 _generated_15:1 _generated_15:2 28.2828

*|NET _generated_16 5.36547e-06PF
C14_1 _generated_16:1 VSS:15 9.21148e-19
C14_2 _generated_16:1 VSS:16 2.98844e-20
C14_3 _generated_16:1 VSS:22 9.68154e-20
C14_4 _generated_16:1 D:4 1.58022e-21
C14_5 _generated_16:1 D:6 2.39886e-19
Cg14_6 _generated_16:1 VSS 3.47201e-18
R14_1 _generated_16:1 _generated_16:2 28.2828

*|NET _generated_17 4.96636e-06PF
C15_1 _generated_17:1 VDD 1.91825e-19
C15_2 _generated_17:1 VDD:5 1.19386e-19
C15_3 _generated_17:1 Y:9 3.81915e-19
C15_4 _generated_17:1 Y:20 5.9231e-20
C15_5 _generated_17:1 D:6 2.39886e-19
C15_6 _generated_17:1 D:8 4.75026e-20
C15_7 _generated_17:1 _generated_16:1 6.0415e-19
Cg15_8 _generated_17:1 VSS 3.32246e-18
R15_1 _generated_17:1 _generated_17:2 28.2828

*
* Instance Section
*
MM1 M1:DRN M1:GATE M1:SRC VSS NMOS_LVT l=0.012u w=0.03u NF=1
MM2 M2:DRN M2:GATE M2:SRC VSS NMOS_LVT l=0.012u w=0.03u NF=1
MM3 M3:DRN M3:GATE M3:SRC VSS NMOS_LVT l=0.012u w=0.03u NF=1
MM4 M4:DRN M4:GATE M4:SRC VSS NMOS_LVT l=0.012u w=0.03u NF=1
MM5 M5:DRN M5:GATE M5:SRC VDD PMOS_LVT l=0.012u w=0.03u NF=1
MM6 M6:DRN M6:GATE M6:SRC VDD PMOS_LVT l=0.012u w=0.03u NF=1
MM7 M7:DRN M7:GATE M7:SRC VDD PMOS_LVT l=0.012u w=0.03u NF=1
MM8 M8:DRN M8:GATE M8:SRC VDD PMOS_LVT l=0.012u w=0.03u NF=1

.ENDS
