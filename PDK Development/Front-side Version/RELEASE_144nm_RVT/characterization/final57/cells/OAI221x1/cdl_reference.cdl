* CANDIDATE independent circuit from preserved2024 prior-layout DSPF.
* All resistive segments collapsed to ideal wires; capacitors omitted for LVS topology.
* Not extracted from the new144nmDUT. Requires independent review before gold admission.
* Source /cedar/cedar_coe/ece-limsk/sw.jung/pdk/LIB_issue_fix/final_w17_pdk/1_fspr/10_liberate_final_fspr_rvt/NETLIST/OAI221x1.spf
.SUBCKT OAI221x1 A B C D E VDD VSS Y
MMM9 Y D MM7:DRN nmos_rvt l=0.012u w=0.03u
MMM0 MM0:DRN A VDD pmos_rvt l=0.012u w=0.03u
MMM8 Y C MM7:DRN nmos_rvt l=0.012u w=0.03u
MMM7 MM7:DRN E MM5:DRN nmos_rvt l=0.012u w=0.03u
MMM6 MM5:DRN B VSS nmos_rvt l=0.012u w=0.03u
MMM5 MM5:DRN A VSS nmos_rvt l=0.012u w=0.03u
MMM4 Y D MM3:DRN pmos_rvt l=0.012u w=0.03u
MMM3 MM3:DRN C VDD pmos_rvt l=0.012u w=0.03u
MMM2 Y E VDD pmos_rvt l=0.012u w=0.03u
MMM1 Y B MM0:DRN pmos_rvt l=0.012u w=0.03u
.ends OAI221x1
