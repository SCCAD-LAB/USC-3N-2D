*
*|DSPF 1.3
*|DESIGN OR2x1
*|DATE "Tue Nov  3 20:53:50 2026"
*|VENDOR "Synopsys"
*|PROGRAM "StarRC"
*|VERSION "X-2025.06-SP1"
*|DIVIDER /
*|DELIMITER :
**FORMAT SPF
*

** COMMENTS

** OPERATING_TEMPERATURE 25
** GLOBAL_TEMPERATURE 25
**
** TCAD_GRD_FILE /cedar/cedar_coe/ece-limsk/yhuang861/GRO/.planning/experiments_migrated_20261022/usc144_github_release_20261103/sources/github_FSPR.nxtgrd
**   TCAD_TIME_STAMP Tue Mar 31 05:07:55 2026
**   TCADGRD_VERSION 89

.SUBCKT OR2x1 VSS VDD Y A B

*|GROUND_NET VSS

*|NET VSS 8.13071e-05PF
*|P (VSS B 0 0.1050 0.0000)
*|I (M1:SRC M1 SRC B 0 0.1620 0.0360)
*|I (M2:DRN M2 DRN B 0 0.0900 0.0360)
*|I (M3:SRC M3 SRC B 0 0.0360 0.0360)
Cg1_1 VSS:5 VSS 2.52098e-19
Cg1_2 VSS:6 VSS 1.78742e-19
Cg1_3 VSS:7 VSS 1.90317e-19
Cg1_4 VSS:12 VSS 2.45987e-18
Cg1_5 VSS:15 VSS 3.0094e-17
Cg1_6 VSS:19 VSS 4.54108e-18
Cg1_7 VSS:21 VSS 6.64024e-18
Cg1_8 VSS:22 VSS 6.56043e-19
Cg1_9 VSS:23 VSS 5.30014e-19
R1_1 VSS VSS:9 25.0832
R1_2 VSS VSS:11 25.0832
R1_3 VSS VSS:22 31.764
R1_4 M1:SRC VSS:18 30000.0
R1_5 M1:SRC VSS:7 30000.0
R1_6 M1:SRC VSS:30 15000.0
R1_7 M2:DRN VSS:17 30000.0
R1_8 M2:DRN VSS:6 30000.0
R1_9 M2:DRN VSS:28 15000.0
R1_10 M3:SRC VSS:16 30000.0
R1_11 M3:SRC VSS:5 30000.0
R1_12 M3:SRC VSS:26 15000.0
R1_13 VSS:5 VSS:26 7.8411
R1_14 VSS:5 VSS:23 12.4587
R1_15 VSS:6 VSS:28 7.8411
R1_16 VSS:6 VSS:22 12.4587
R1_17 VSS:7 VSS:30 7.8411
R1_18 VSS:7 VSS:12 12.4587
R1_19 VSS:8 VSS:21 17.9166
R1_20 VSS:8 VSS:9 25.0832
R1_21 VSS:8 VSS:23 31.764
R1_22 VSS:9 VSS:10 63.5281
R1_23 VSS:10 VSS:23 50.1851
R1_24 VSS:10 VSS:22 50.1851
R1_25 VSS:11 VSS:12 31.764
R1_26 VSS:11 VSS:13 25.0832
R1_27 VSS:12 VSS:14 50.1851
R1_28 VSS:12 VSS:22 44.9024
R1_29 VSS:13 VSS:14 63.5281
R1_30 VSS:13 VSS:32 17.9166
R1_31 VSS:14 VSS:25 39.6198
R1_32 VSS:15 VSS:19 7778.54
R1_33 VSS:16 VSS:26 7.8411
R1_34 VSS:16 VSS:27 1.77981
R1_35 VSS:17 VSS:28 7.8411
R1_36 VSS:17 VSS:29 1.77981
R1_37 VSS:18 VSS:30 7.8411
R1_38 VSS:18 VSS:31 1.77981
R1_39 VSS:19 VSS:20 2332.32
R1_40 VSS:23 VSS:24 34.3372
R1_41 VSS:23 VSS:15 0.01

*|NET VDD 4.73096e-05PF
*|P (VDD B 0 0.1050 0.1440)
*|I (M4:SRC M4 SRC B 0 0.1620 0.1080)
*|I (M6:SRC M6 SRC B 0 0.0360 0.1080)
C2_1 VDD VSS:12 7.79004e-20
C2_2 VDD:11 VSS:12 1.62462e-19
C2_3 VDD:14 VSS:12 6.70874e-21
C2_4 VDD:16 VSS:12 3.96303e-21
C2_5 VDD:17 VSS:12 6.38861e-20
C2_6 VDD VSS:15 1.26433e-18
C2_7 VDD:4 VSS:15 8.0263e-19
C2_8 VDD:11 VSS:15 3.57233e-19
C2_9 VDD:17 VSS:15 1.49938e-18
C2_10 VDD VSS:21 1.13801e-18
C2_11 VDD:11 VSS:21 2.76282e-20
C2_12 VDD VSS:23 8.78916e-22
C2_13 VDD:14 VSS:23 3.86285e-21
C2_14 VDD:17 VSS:23 1.20446e-19
Cg2_15 VDD VSS 7.00165e-18
Cg2_16 VDD:4 VSS 2.52098e-19
Cg2_17 VDD:5 VSS 2.52098e-19
Cg2_18 VDD:11 VSS 1.13932e-17
Cg2_19 VDD:14 VSS 5.43919e-21
Cg2_20 VDD:16 VSS 1.24483e-20
Cg2_21 VDD:17 VSS 7.87308e-19
R2_1 VDD VDD:7 25.0832
R2_2 VDD VDD:9 63.5281
R2_3 VDD VDD:10 25.0832
R2_4 VDD VDD:15 38473.3
R2_5 M4:SRC VDD:16 30000.0
R2_6 M4:SRC VDD:5 30000.0
R2_7 M4:SRC VDD:22 15000.0
R2_8 M6:SRC VDD:14 30000.0
R2_9 M6:SRC VDD:4 30000.0
R2_10 M6:SRC VDD:20 15000.0
R2_11 VDD:4 VDD:20 7.8411
R2_12 VDD:4 VDD:21 1.77981
R2_13 VDD:5 VDD:22 7.8411
R2_14 VDD:5 VDD:23 1.77981
R2_15 VDD:6 VDD:24 17.9166
R2_16 VDD:6 VDD:7 25.0832
R2_17 VDD:6 VDD:17 31.764
R2_18 VDD:7 VDD:8 63.5281
R2_19 VDD:8 VDD:17 50.1851
R2_20 VDD:8 VDD:9 55.4677
R2_21 VDD:9 VDD:11 50.1851
R2_22 VDD:10 VDD:11 31.764
R2_23 VDD:10 VDD:12 25.0832
R2_24 VDD:11 VDD:13 50.1851
R2_25 VDD:11 VDD:16 12.4587
R2_26 VDD:12 VDD:13 63.5281
R2_27 VDD:12 VDD:25 17.9166
R2_28 VDD:13 VDD:19 39.6198
R2_29 VDD:14 VDD:20 7.8411
R2_30 VDD:14 VDD:17 12.4587
R2_31 VDD:16 VDD:22 7.8411
R2_32 VDD:17 VDD:18 34.3372

*|NET Y 1.80044e-05PF
*|P (Y B 0 0.1890 0.0720)
*|I (M1:DRN M1 DRN B 0 0.1740 0.0360)
*|I (M4:DRN M4 DRN B 0 0.1740 0.1080)
C3_1 M1:DRN VSS:7 3.78986e-20
C3_2 Y:12 VSS:7 1.77132e-19
C3_3 M1:DRN VSS:12 5.55438e-20
C3_4 Y:4 VSS:12 2.32339e-18
C3_5 Y:12 VSS:12 1.88848e-19
C3_6 Y:12 VSS:15 6.06473e-19
C3_7 Y:12 VSS:19 7.77805e-20
C3_8 Y:12 VSS:20 1.98849e-19
C3_9 Y:4 VSS:21 1.68234e-19
C3_10 Y:12 VSS:21 1.43102e-18
C3_11 M1:DRN VSS:22 1.14924e-20
C3_12 Y:12 VSS:22 9.52251e-21
C3_13 Y:5 VDD 1.86937e-19
C3_14 Y:12 VDD 1.55977e-18
C3_15 M4:DRN VDD:5 2.82443e-20
C3_16 Y:12 VDD:5 8.37831e-20
C3_17 M4:DRN VDD:11 3.81728e-20
C3_18 Y:5 VDD:11 1.05946e-18
C3_19 Y:12 VDD:11 1.08178e-19
Cg3_20 Y:4 VSS 3.15906e-19
Cg3_21 Y:5 VSS 2.8933e-19
Cg3_22 Y:6 VSS 1.78742e-19
Cg3_23 Y:7 VSS 1.78742e-19
Cg3_24 Y:12 VSS 3.20161e-18
R3_1 Y Y:10 21.4999
R3_2 Y Y:8 21.4999
R3_3 M1:DRN Y:6 30000.0
R3_4 M1:DRN Y:4 30000.0
R3_5 M1:DRN Y:9 15000.0
R3_6 M4:DRN Y:7 30000.0
R3_7 M4:DRN Y:5 30000.0
R3_8 M4:DRN Y:11 15000.0
R3_9 Y:4 Y:9 9.78801
R3_10 Y:5 Y:11 9.78801
R3_11 Y:6 Y:9 9.78801
R3_12 Y:7 Y:11 9.78801
R3_13 Y:8 Y:9 63.5281
R3_14 Y:8 Y:12 7.8833
R3_15 Y:10 Y:11 63.5281
R3_16 Y:10 Y:13 7.94303

*|NET A 1.84724e-05PF
*|P (A B 0 0.0210 0.0720)
*|I (M3:GATE M3 GATE I 3.6e-19 0.0420 0.0360)
*|I (M6:GATE M6 GATE I 3.6e-19 0.0420 0.1080)
C4_1 A:10 VSS:5 2.33814e-19
C4_2 A:4 VSS:12 4.61602e-19
C4_3 A:5 VSS:12 7.89427e-21
C4_4 A:10 VSS:12 9.63817e-20
C4_5 A:10 VSS:15 9.45727e-19
C4_6 A:10 VSS:16 4.85975e-20
C4_7 A:4 VSS:21 2.75992e-20
C4_8 A:10 VSS:21 1.48246e-18
C4_9 A:8 VSS:23 9.16124e-19
C4_10 A:10 VSS:23 6.15563e-19
C4_11 A:4 VDD 4.02543e-21
C4_12 A:7 VDD 4.85422e-20
C4_13 A:8 VDD 2.83023e-20
C4_14 A:10 VDD 1.4903e-18
C4_15 A:10 VDD:4 1.1494e-19
C4_16 A:7 VDD:11 1.15802e-19
C4_17 A:8 VDD:14 1.48933e-20
C4_18 A:10 VDD:14 1.14929e-19
C4_19 A:8 VDD:17 1.58128e-18
C4_20 A:10 VDD:17 4.73109e-19
Cg4_21 A:4 VSS 1.09486e-19
Cg4_22 A:6 VSS 3.4119e-19
Cg4_23 A:7 VSS 2.31874e-19
Cg4_24 A:8 VSS 1.99342e-19
Cg4_25 A:10 VSS 3.65468e-18
R4_1 A A:10 29.3832
R4_2 A A:13 29.4429
R4_3 A A:9 63.5281
R4_4 M3:GATE A:5 7.57576
R4_5 M3:GATE A:4 7.57576
R4_6 M6:GATE A:7 13.1313
R4_7 M6:GATE A:6 7.57576
R4_8 A:4 A:11 5.55556
R4_9 A:5 A:8 10.6061
R4_10 A:6 A:8 10.6061
R4_11 A:8 A:9 27.7339
R4_12 A:9 A:12 7.92396

*|NET B 1.99239e-05PF
*|P (B B 0 0.1050 0.0720)
*|I (M2:GATE M2 GATE I 3.6e-19 0.0840 0.0360)
*|I (M5:GATE M5 GATE I 3.6e-19 0.0840 0.1080)
C5_1 B:11 VSS:6 1.14564e-19
C5_2 B:4 VSS:12 4.61602e-19
C5_3 B:5 VSS:12 7.89427e-21
C5_4 B:11 VSS:12 8.83916e-20
C5_5 B:9 VSS:15 4.73412e-19
C5_6 B:11 VSS:15 3.72984e-19
C5_7 B:11 VSS:17 3.95537e-20
C5_8 B:11 VSS:19 3.66301e-20
C5_9 B:4 VSS:21 8.94547e-20
C5_10 B:11 VSS:21 1.51075e-18
C5_11 B:4 VSS:22 1.02721e-19
C5_12 B:9 VSS:22 7.92338e-19
C5_13 B:11 VSS:22 9.5346e-19
C5_14 B:11 Y:12 9.97452e-19
Cg5_15 B:4 VSS 2.41021e-19
Cg5_16 B:6 VSS 3.4119e-19
Cg5_17 B:8 VSS 4.28628e-19
Cg5_18 B:9 VSS 1.9145e-19
Cg5_19 B:11 VSS 1.90364e-18
R5_1 B B:11 29.3832
R5_2 B B:14 12.8402
R5_3 B B:10 63.5281
R5_4 M2:GATE B:5 7.57576
R5_5 M2:GATE B:4 7.57576
R5_6 M5:GATE B:7 7.57576
R5_7 M5:GATE B:6 7.57576
R5_8 B:4 B:12 5.55556
R5_9 B:5 B:9 10.6061
R5_10 B:6 B:9 10.6061
R5_11 B:7 B:8 5.55556
R5_12 B:9 B:10 27.7339
R5_13 B:10 B:13 7.92396

*|NET 10 4.60393e-07PF
*|I (M5:SRC M5 SRC B 0 0.0780 0.1080)
*|I (M6:DRN M6 DRN B 0 0.0480 0.1080)
C7_1 M6:DRN VDD 1.18364e-19
C7_2 M6:DRN VDD:4 2.82443e-20
C7_3 M6:DRN VDD:17 2.13821e-20
R7_1 M5:SRC M6:DRN 15000.0

*|NET 4 5.1591e-05PF
*|I (M1:GATE M1 GATE I 3.6e-19 0.1680 0.0360)
*|I (M2:SRC M2 SRC B 0 0.0780 0.0360)
*|I (M3:DRN M3 DRN B 0 0.0480 0.0360)
*|I (M4:GATE M4 GATE I 3.6e-19 0.1680 0.1080)
*|I (M5:DRN M5 DRN B 0 0.0900 0.1080)
C8_1 M3:DRN VSS:5 2.82443e-20
C8_2 4:22 VSS:5 8.37832e-20
C8_3 4:7 VSS:7 1.25618e-18
C8_4 M3:DRN VSS:12 2.08295e-20
C8_5 4:6 VSS:12 7.192e-19
C8_6 4:7 VSS:12 7.08412e-19
C8_7 4:8 VSS:12 1.86805e-19
C8_8 4:11 VSS:12 2.32548e-18
C8_9 4:13 VSS:12 9.82685e-19
C8_10 4:22 VSS:12 6.64965e-20
C8_11 4:23 VSS:12 1.84286e-20
C8_12 4:24 VSS:12 4.31423e-19
C8_13 4:11 VSS:15 1.82129e-20
C8_14 4:22 VSS:15 4.41875e-19
C8_15 4:23 VSS:15 3.32558e-19
C8_16 4:24 VSS:15 2.38247e-19
C8_17 4:11 VSS:17 3.18141e-20
C8_18 4:14 VSS:17 2.82443e-20
C8_19 4:11 VSS:19 1.82139e-19
C8_20 4:6 VSS:21 8.94107e-20
C8_21 4:11 VSS:21 1.81118e-19
C8_22 4:22 VSS:21 1.20404e-18
C8_23 4:23 VSS:21 6.4041e-19
C8_24 4:24 VSS:21 5.88822e-19
C8_25 M5:DRN VSS:22 3.59134e-21
C8_26 4:6 VSS:22 1.17464e-19
C8_27 4:12 VSS:22 1.14544e-19
C8_28 4:23 VSS:22 1.18172e-20
C8_29 M3:DRN VSS:23 2.13821e-20
C8_30 4:22 VSS:23 9.95344e-20
C8_31 4:10 VDD 1.27987e-19
C8_32 4:12 VDD 1.62636e-19
C8_33 4:13 VDD 2.83023e-20
C8_34 4:22 VDD 5.06959e-20
C8_35 4:23 VDD 6.94106e-18
C8_36 4:24 VDD 5.882e-20
C8_37 4:22 VDD:4 4.55222e-20
C8_38 4:23 VDD:4 4.4138e-20
C8_39 4:9 VDD:5 1.24237e-18
C8_40 4:23 VDD:5 1.17159e-19
C8_41 4:24 VDD:5 6.62022e-20
C8_42 4:8 VDD:11 1.83918e-19
C8_43 4:9 VDD:11 6.89692e-19
C8_44 4:10 VDD:11 3.72645e-19
C8_45 4:12 VDD:11 1.06277e-18
C8_46 4:13 VDD:11 1.58755e-18
C8_47 4:23 VDD:11 1.77131e-19
C8_48 4:24 VDD:11 2.0744e-19
C8_49 4:13 VDD:16 1.52324e-20
C8_50 4:23 VDD:16 5.71552e-20
C8_51 4:24 VDD:16 8.55638e-20
C8_52 4:22 VDD:17 6.36496e-20
C8_53 4:23 VDD:17 5.05156e-20
C8_54 4:7 Y:12 2.19599e-19
C8_55 4:8 Y:12 2.26222e-19
C8_56 4:9 Y:12 1.40777e-19
C8_57 4:13 Y:12 2.90465e-19
C8_58 4:22 Y:12 6.13234e-20
C8_59 4:23 Y:12 7.89974e-19
C8_60 4:24 Y:12 1.88555e-18
C8_61 4:22 A:10 3.61413e-18
C8_62 4:23 A:10 8.57339e-19
C8_63 4:24 A:10 2.04647e-20
C8_64 4:11 B:5 6.89692e-19
C8_65 4:14 B:5 1.24456e-18
C8_66 4:22 B:5 1.33321e-19
C8_67 4:11 B:6 1.83918e-19
C8_68 4:22 B:6 1.53517e-19
C8_69 4:23 B:6 1.00313e-19
C8_70 4:23 B:7 7.93247e-20
C8_71 4:23 B:8 2.71821e-20
C8_72 M5:DRN B:9 1.71316e-20
C8_73 4:12 B:9 1.6205e-18
C8_74 4:23 B:9 1.24808e-19
C8_75 4:24 B:9 1.82924e-20
C8_76 M5:DRN B:11 7.01306e-22
C8_77 4:11 B:11 1.31772e-19
C8_78 4:12 B:11 9.20157e-20
C8_79 4:14 B:11 8.37832e-20
C8_80 4:15 B:11 2.36591e-21
C8_81 4:22 B:11 2.97742e-18
C8_82 4:23 B:11 1.67118e-18
C8_83 4:24 B:11 1.42497e-18
C8_84 4:11 M6:DRN 1.57561e-19
C8_85 4:22 M6:DRN 6.25005e-20
C8_86 4:23 M6:DRN 7.23414e-20
Cg8_87 4:6 VSS 1.00945e-19
Cg8_88 4:8 VSS 9.8281e-19
Cg8_89 4:10 VSS 1.68609e-19
Cg8_90 4:11 VSS 3.4736e-19
Cg8_91 4:12 VSS 2.35516e-19
Cg8_92 4:13 VSS 4.74767e-19
Cg8_93 4:14 VSS 2.52098e-19
Cg8_94 4:15 VSS 1.78742e-19
Cg8_95 4:22 VSS 1.44128e-18
Cg8_96 4:23 VSS 1.25745e-18
Cg8_97 4:24 VSS 8.93115e-19
R8_1 M1:GATE 4:7 7.57576
R8_2 M1:GATE 4:6 7.57576
R8_3 M2:SRC 4:14 30000.0
R8_4 M2:SRC 4:11 30000.0
R8_5 M2:SRC 4:19 15000.0
R8_6 M3:DRN 4:14 30000.0
R8_7 M3:DRN 4:11 30000.0
R8_8 M3:DRN 4:19 15000.0
R8_9 M4:GATE 4:9 7.57576
R8_10 M4:GATE 4:8 7.57576
R8_11 M5:DRN 4:12 30000.0
R8_12 M5:DRN 4:27 20089.3
R8_13 M5:DRN 4:15 59210.5
R8_14 M5:DRN 4:21 30000.0
R8_15 4:6 4:25 5.55556
R8_16 4:7 4:13 10.6061
R8_17 4:8 4:13 10.6061
R8_18 4:9 4:10 5.55556
R8_19 4:11 4:19 9.78705
R8_20 4:12 4:21 14.1199
R8_21 4:12 4:27 8.62521
R8_22 4:13 4:17 27.7339
R8_23 4:14 4:19 9.78705
R8_24 4:15 4:21 5.45756
R8_25 4:16 4:17 63.5281
R8_26 4:16 4:24 3.58332
R8_27 4:16 4:23 25.8596
R8_28 4:17 4:26 7.92396
R8_29 4:18 4:19 63.5281
R8_30 4:18 4:28 5.9722
R8_31 4:18 4:22 47.3595
R8_32 4:20 4:21 63.5281
R8_33 4:20 4:22 25.0832
R8_34 4:20 4:23 25.0832
R8_35 4:21 4:27 43800.0

*|NET _generated_11 2.86348e-06PF
C9_1 _generated_11:1 VSS:15 6.61239e-19
C9_2 _generated_11:1 VSS:21 2.25577e-20
C9_3 _generated_11:1 VSS:23 3.44976e-19
C9_4 _generated_11:1 A:10 3.06042e-19
Cg9_5 _generated_11:1 VSS 9.49624e-19
R9_1 _generated_11:1 _generated_11:2 28.2828

*|NET _generated_12 3.08088e-06PF
C10_1 _generated_12:1 VSS:12 1.47021e-19
C10_2 _generated_12:1 VSS:15 5.65589e-19
C10_3 _generated_12:1 VDD 4.89892e-20
C10_4 _generated_12:1 VDD:11 1.18927e-19
C10_5 _generated_12:1 VDD:17 3.74453e-19
C10_6 _generated_12:1 A:10 3.15962e-19
C10_7 _generated_12:1 _generated_11:1 5.79044e-19
Cg10_8 _generated_12:1 VSS 9.3089e-19
R10_1 _generated_12:1 _generated_12:2 28.2828

*|NET _generated_13 3.33966e-06PF
C11_1 _generated_13:1 VSS:12 9.22932e-19
C11_2 _generated_13:1 VSS:15 1.80443e-19
C11_3 _generated_13:1 VSS:21 8.73825e-20
C11_4 _generated_13:1 M5:DRN 1.24483e-20
C11_5 _generated_13:1 4:6 3.12363e-20
C11_6 _generated_13:1 4:7 4.74065e-20
C11_7 _generated_13:1 4:8 9.05603e-20
C11_8 _generated_13:1 4:23 1.24574e-19
C11_9 _generated_13:1 4:24 2.27958e-20
Cg11_10 _generated_13:1 VSS 1.2521e-18
R11_1 _generated_13:1 _generated_13:2 28.2828

*|NET _generated_14 3.24298e-06PF
C12_1 _generated_14:1 VSS:15 3.89024e-19
C12_2 _generated_14:1 VDD 7.13829e-20
C12_3 _generated_14:1 VDD:11 4.93873e-19
C12_4 _generated_14:1 4:8 1.5545e-19
C12_5 _generated_14:1 4:9 5.92231e-20
C12_6 _generated_14:1 4:10 3.10326e-20
C12_7 _generated_14:1 4:23 2.00685e-19
C12_8 _generated_14:1 4:24 1.21791e-19
C12_9 _generated_14:1 _generated_13:1 5.67777e-19
Cg12_10 _generated_14:1 VSS 1.15274e-18
R12_1 _generated_14:1 _generated_14:2 28.2828

*|NET _generated_15 5.30916e-06PF
C13_1 _generated_15:1 VSS:12 4.62142e-19
C13_2 _generated_15:1 VSS:15 2.98844e-20
C13_3 _generated_15:1 VSS:21 8.26703e-20
C13_4 _generated_15:1 VSS:22 5.66835e-22
C13_5 _generated_15:1 Y:4 3.81915e-19
C13_6 _generated_15:1 Y:12 5.48053e-20
C13_7 _generated_15:1 4:6 4.75026e-20
C13_8 _generated_15:1 4:8 2.39886e-19
Cg13_9 _generated_15:1 VSS 3.40563e-18
R13_1 _generated_15:1 _generated_15:2 28.2828

*|NET _generated_16 4.96686e-06PF
C14_1 _generated_16:1 VDD 1.91825e-19
C14_2 _generated_16:1 VDD:11 1.1978e-19
C14_3 _generated_16:1 Y:5 3.81915e-19
C14_4 _generated_16:1 Y:12 5.9343e-20
C14_5 _generated_16:1 4:8 2.39886e-19
C14_6 _generated_16:1 4:10 4.75026e-20
C14_7 _generated_16:1 _generated_15:1 6.0415e-19
Cg14_8 _generated_16:1 VSS 3.32246e-18
R14_1 _generated_16:1 _generated_16:2 28.2828

*
* Instance Section
*
MM1 M1:DRN M1:GATE M1:SRC VSS NMOS_LVT l=0.012u w=0.03u NF=1
MM2 M2:DRN M2:GATE M2:SRC VSS NMOS_LVT l=0.012u w=0.03u NF=1
MM3 M3:DRN M3:GATE M3:SRC VSS NMOS_LVT l=0.012u w=0.03u NF=1
MM4 M4:DRN M4:GATE M4:SRC VDD PMOS_LVT l=0.012u w=0.03u NF=1
MM5 M5:DRN M5:GATE M5:SRC VDD PMOS_LVT l=0.012u w=0.03u NF=1
MM6 M6:DRN M6:GATE M6:SRC VDD PMOS_LVT l=0.012u w=0.03u NF=1

.ENDS
