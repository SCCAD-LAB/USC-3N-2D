*
*|DSPF 1.3
*|DESIGN BUFx4
*|DATE "Tue Nov  3 20:51:54 2026"
*|VENDOR "Synopsys"
*|PROGRAM "StarRC"
*|VERSION "X-2025.06-SP1"
*|DIVIDER /
*|DELIMITER :
**FORMAT SPF
*

** COMMENTS

** OPERATING_TEMPERATURE 25
** GLOBAL_TEMPERATURE 25
**
** TCAD_GRD_FILE /cedar/cedar_coe/ece-limsk/yhuang861/GRO/.planning/experiments_migrated_20261022/usc144_github_release_20261103/sources/github_FSPR.nxtgrd
**   TCAD_TIME_STAMP Tue Mar 31 05:07:55 2026
**   TCADGRD_VERSION 89

.SUBCKT BUFx4 VSS VDD A Y

*|GROUND_NET VSS

*|NET VSS 7.74247e-05PF
*|P (VSS B 0 0.2100 0.0000)
*|I (M1:DRN M1 DRN B 0 0.3420 0.0360)
*|I (M2:SRC M2 SRC B 0 0.2880 0.0360)
*|I (M3:DRN M3 DRN B 0 0.2580 0.0360)
*|I (M4:SRC M4 SRC B 0 0.2040 0.0360)
*|I (M5:DRN M5 DRN B 0 0.1740 0.0360)
*|I (M6:SRC M6 SRC B 0 0.1200 0.0360)
*|I (M7:DRN M7 DRN B 0 0.0900 0.0360)
*|I (M8:SRC M8 SRC B 0 0.0360 0.0360)
Cg1_1 VSS:10 VSS 2.68769e-19
Cg1_2 VSS:11 VSS 2.77026e-19
Cg1_3 VSS:12 VSS 2.68769e-19
Cg1_4 VSS:13 VSS 2.77026e-19
Cg1_5 VSS:14 VSS 1.78742e-19
Cg1_6 VSS:20 VSS 3.45383e-18
Cg1_7 VSS:26 VSS 1.03958e-17
Cg1_8 VSS:27 VSS 5.73971e-19
Cg1_9 VSS:28 VSS 5.22713e-19
Cg1_10 VSS:29 VSS 5.26914e-19
Cg1_11 VSS:30 VSS 4.93182e-19
R1_1 VSS VSS:18 37.6249
R1_2 VSS VSS:17 12.5416
R1_3 M1:DRN VSS:25 30000.0
R1_4 M1:DRN VSS:14 30000.0
R1_5 M1:DRN VSS:41 15000.0
R1_6 M2:SRC VSS:24 30000.0
R1_7 M2:SRC VSS:13 30000.0
R1_8 M2:SRC VSS:39 15000.0
R1_9 M3:DRN VSS:24 30000.0
R1_10 M3:DRN VSS:13 30000.0
R1_11 M3:DRN VSS:39 15000.0
R1_12 M4:SRC VSS:23 30000.0
R1_13 M4:SRC VSS:12 30000.0
R1_14 M4:SRC VSS:37 15000.0
R1_15 M5:DRN VSS:23 30000.0
R1_16 M5:DRN VSS:12 30000.0
R1_17 M5:DRN VSS:37 15000.0
R1_18 M6:SRC VSS:22 30000.0
R1_19 M6:SRC VSS:11 30000.0
R1_20 M6:SRC VSS:35 15000.0
R1_21 M7:DRN VSS:22 30000.0
R1_22 M7:DRN VSS:11 30000.0
R1_23 M7:DRN VSS:35 15000.0
R1_24 M8:SRC VSS:21 30000.0
R1_25 M8:SRC VSS:10 30000.0
R1_26 M8:SRC VSS:33 15000.0
R1_27 VSS:10 VSS:33 7.8411
R1_28 VSS:10 VSS:30 12.4587
R1_29 VSS:11 VSS:35 7.84041
R1_30 VSS:11 VSS:29 12.4587
R1_31 VSS:12 VSS:37 7.84041
R1_32 VSS:12 VSS:28 12.4587
R1_33 VSS:13 VSS:39 7.84041
R1_34 VSS:13 VSS:27 12.4587
R1_35 VSS:14 VSS:41 7.8411
R1_36 VSS:14 VSS:20 12.4587
R1_37 VSS:15 VSS:26 17.9166
R1_38 VSS:15 VSS:16 50.1665
R1_39 VSS:15 VSS:30 31.764
R1_40 VSS:16 VSS:17 50.1665
R1_41 VSS:16 VSS:29 31.764
R1_42 VSS:17 VSS:28 31.764
R1_43 VSS:18 VSS:19 50.1665
R1_44 VSS:18 VSS:27 31.764
R1_45 VSS:19 VSS:20 31.764
R1_46 VSS:19 VSS:43 17.9166
R1_47 VSS:20 VSS:27 100.37
R1_48 VSS:20 VSS:32 34.3372
R1_49 VSS:21 VSS:33 7.8411
R1_50 VSS:21 VSS:34 1.77981
R1_51 VSS:22 VSS:35 7.84041
R1_52 VSS:22 VSS:36 1.77981
R1_53 VSS:23 VSS:37 7.84041
R1_54 VSS:23 VSS:38 1.77981
R1_55 VSS:24 VSS:39 7.84041
R1_56 VSS:24 VSS:40 1.77981
R1_57 VSS:25 VSS:41 7.8411
R1_58 VSS:25 VSS:42 1.77981
R1_59 VSS:27 VSS:28 100.37
R1_60 VSS:28 VSS:29 100.37
R1_61 VSS:29 VSS:30 100.37
R1_62 VSS:30 VSS:31 34.3372

*|NET VDD 8.45602e-05PF
*|P (VDD B 0 0.2100 0.1440)
*|I (M10:SRC M10 SRC B 0 0.2880 0.1080)
*|I (M11:DRN M11 DRN B 0 0.2580 0.1080)
*|I (M12:SRC M12 SRC B 0 0.2040 0.1080)
*|I (M13:DRN M13 DRN B 0 0.1740 0.1080)
*|I (M14:SRC M14 SRC B 0 0.1200 0.1080)
*|I (M15:DRN M15 DRN B 0 0.0900 0.1080)
*|I (M16:SRC M16 SRC B 0 0.0360 0.1080)
*|I (M9:DRN M9 DRN B 0 0.3420 0.1080)
C2_1 VDD:20 VSS:20 4.19119e-19
C2_2 VDD:21 VSS:20 6.70033e-21
C2_3 VDD:25 VSS:20 2.00992e-20
C2_4 VDD:26 VSS:20 7.79004e-20
C2_5 VDD:30 VSS:20 6.39187e-20
C2_6 VDD:20 VSS:26 2.76282e-20
C2_7 VDD:26 VSS:26 5.95297e-19
C2_8 VDD:24 VSS:27 2.24891e-20
C2_9 VDD:27 VSS:27 4.65622e-19
C2_10 VDD:23 VSS:28 2.26115e-20
C2_11 VDD:28 VSS:28 4.49535e-19
C2_12 VDD:22 VSS:29 2.24891e-20
C2_13 VDD:29 VSS:29 4.65622e-19
C2_14 VDD:21 VSS:30 2.26115e-20
C2_15 VDD:30 VSS:30 4.49535e-19
Cg2_16 VDD:10 VSS 2.68918e-19
Cg2_17 VDD:11 VSS 2.77231e-19
Cg2_18 VDD:12 VSS 2.68918e-19
Cg2_19 VDD:13 VSS 2.77231e-19
Cg2_20 VDD:14 VSS 1.78742e-19
Cg2_21 VDD:20 VSS 1.88471e-17
Cg2_22 VDD:21 VSS 5.43919e-21
Cg2_23 VDD:26 VSS 1.03659e-17
Cg2_24 VDD:27 VSS 7.6747e-19
Cg2_25 VDD:28 VSS 8.4154e-19
Cg2_26 VDD:29 VSS 8.38575e-19
Cg2_27 VDD:30 VSS 8.09118e-19
R2_1 VDD VDD:18 37.6249
R2_2 VDD VDD:17 12.5416
R2_3 M10:SRC VDD:24 30000.0
R2_4 M10:SRC VDD:13 30000.0
R2_5 M10:SRC VDD:39 15000.0
R2_6 M11:DRN VDD:24 30000.0
R2_7 M11:DRN VDD:13 30000.0
R2_8 M11:DRN VDD:39 15000.0
R2_9 M12:SRC VDD:23 30000.0
R2_10 M12:SRC VDD:12 30000.0
R2_11 M12:SRC VDD:37 15000.0
R2_12 M13:DRN VDD:23 30000.0
R2_13 M13:DRN VDD:12 30000.0
R2_14 M13:DRN VDD:37 15000.0
R2_15 M14:SRC VDD:22 30000.0
R2_16 M14:SRC VDD:11 30000.0
R2_17 M14:SRC VDD:35 15000.0
R2_18 M15:DRN VDD:22 30000.0
R2_19 M15:DRN VDD:11 30000.0
R2_20 M15:DRN VDD:35 15000.0
R2_21 M16:SRC VDD:21 30000.0
R2_22 M16:SRC VDD:10 30000.0
R2_23 M16:SRC VDD:33 15000.0
R2_24 M9:DRN VDD:25 30000.0
R2_25 M9:DRN VDD:14 30000.0
R2_26 M9:DRN VDD:41 15000.0
R2_27 VDD:10 VDD:33 7.8411
R2_28 VDD:10 VDD:34 1.77981
R2_29 VDD:11 VDD:35 7.84041
R2_30 VDD:11 VDD:36 1.77981
R2_31 VDD:12 VDD:37 7.84041
R2_32 VDD:12 VDD:38 1.77981
R2_33 VDD:13 VDD:39 7.84041
R2_34 VDD:13 VDD:40 1.77981
R2_35 VDD:14 VDD:41 7.8411
R2_36 VDD:14 VDD:42 1.77981
R2_37 VDD:15 VDD:26 17.9166
R2_38 VDD:15 VDD:16 50.1665
R2_39 VDD:15 VDD:30 31.764
R2_40 VDD:16 VDD:17 50.1665
R2_41 VDD:16 VDD:29 31.764
R2_42 VDD:17 VDD:28 31.764
R2_43 VDD:18 VDD:19 50.1665
R2_44 VDD:18 VDD:27 31.764
R2_45 VDD:19 VDD:20 31.764
R2_46 VDD:19 VDD:43 17.9166
R2_47 VDD:20 VDD:25 12.4587
R2_48 VDD:20 VDD:27 100.37
R2_49 VDD:20 VDD:32 34.3372
R2_50 VDD:21 VDD:33 7.8411
R2_51 VDD:21 VDD:30 12.4587
R2_52 VDD:22 VDD:35 7.84041
R2_53 VDD:22 VDD:29 12.4587
R2_54 VDD:23 VDD:37 7.84041
R2_55 VDD:23 VDD:28 12.4587
R2_56 VDD:24 VDD:39 7.84041
R2_57 VDD:24 VDD:27 12.4587
R2_58 VDD:25 VDD:41 7.8411
R2_59 VDD:27 VDD:28 100.37
R2_60 VDD:28 VDD:29 100.37
R2_61 VDD:29 VDD:30 100.37
R2_62 VDD:30 VDD:31 34.3372

*|NET A 3.67869e-05PF
*|P (A B 0 0.0210 0.0720)
*|I (M13:GATE M13 GATE I 3.6e-19 0.1680 0.1080)
*|I (M14:GATE M14 GATE I 3.6e-19 0.1260 0.1080)
*|I (M15:GATE M15 GATE I 3.6e-19 0.0840 0.1080)
*|I (M16:GATE M16 GATE I 3.6e-19 0.0420 0.1080)
*|I (M5:GATE M5 GATE I 3.6e-19 0.1680 0.0360)
*|I (M6:GATE M6 GATE I 3.6e-19 0.1260 0.0360)
*|I (M7:GATE M7 GATE I 3.6e-19 0.0840 0.0360)
*|I (M8:GATE M8 GATE I 3.6e-19 0.0420 0.0360)
C3_1 A VSS:10 2.57918e-19
C3_2 A VSS:20 9.50471e-20
C3_3 A:10 VSS:20 4.60642e-19
C3_4 A:11 VSS:20 7.89427e-21
C3_5 A:14 VSS:20 4.59524e-19
C3_6 A:15 VSS:20 7.89427e-21
C3_7 A:19 VSS:20 4.59524e-19
C3_8 A:20 VSS:20 7.89427e-21
C3_9 A:24 VSS:20 4.59524e-19
C3_10 A:25 VSS:20 7.89427e-21
C3_11 A:36 VSS:20 2.22995e-20
C3_12 A VSS:21 5.02191e-20
C3_13 A VSS:26 1.41614e-18
C3_14 A:10 VSS:26 2.2911e-20
C3_15 A:36 VSS:26 1.00511e-18
C3_16 A:36 VSS:29 3.06792e-19
C3_17 A VSS:30 5.78851e-19
C3_18 A:36 VSS:30 2.41841e-19
C3_19 A:37 VDD:10 1.1494e-19
C3_20 A:13 VDD:20 1.14913e-19
C3_21 A:18 VDD:20 1.15217e-19
C3_22 A:23 VDD:20 1.15217e-19
C3_23 A:28 VDD:20 1.15217e-19
C3_24 A:37 VDD:21 1.27169e-19
C3_25 A:13 VDD:26 5.72243e-20
C3_26 A:18 VDD:26 4.17741e-20
C3_27 A:23 VDD:26 4.17741e-20
C3_28 A:28 VDD:26 4.17741e-20
C3_29 A:36 VDD:26 1.00511e-18
C3_30 A:37 VDD:26 1.42406e-18
C3_31 A:36 VDD:29 6.63905e-20
C3_32 A:36 VDD:30 9.9272e-21
C3_33 A:37 VDD:30 4.80838e-19
Cg3_34 A VSS 1.69062e-18
Cg3_35 A:10 VSS 1.08842e-19
Cg3_36 A:12 VSS 3.4119e-19
Cg3_37 A:13 VSS 2.25021e-19
Cg3_38 A:14 VSS 1.09775e-19
Cg3_39 A:16 VSS 3.4119e-19
Cg3_40 A:18 VSS 2.27134e-19
Cg3_41 A:19 VSS 1.09775e-19
Cg3_42 A:21 VSS 3.4119e-19
Cg3_43 A:23 VSS 2.27134e-19
Cg3_44 A:24 VSS 1.09775e-19
Cg3_45 A:26 VSS 3.4119e-19
Cg3_46 A:28 VSS 2.27134e-19
Cg3_47 A:29 VSS 3.24935e-19
Cg3_48 A:31 VSS 7.88992e-20
Cg3_49 A:33 VSS 7.39304e-20
Cg3_50 A:36 VSS 2.10487e-18
Cg3_51 A:37 VSS 1.76555e-18
R3_1 A A:30 12.5416
R3_2 A A:37 29.4429
R3_3 A A:43 27.5916
R3_4 M13:GATE A:27 7.57576
R3_5 M13:GATE A:26 7.57576
R3_6 M14:GATE A:22 7.57576
R3_7 M14:GATE A:21 7.57576
R3_8 M15:GATE A:17 7.57576
R3_9 M15:GATE A:16 7.57576
R3_10 M16:GATE A:13 13.1313
R3_11 M16:GATE A:12 7.57576
R3_12 M5:GATE A:25 7.57576
R3_13 M5:GATE A:24 7.57576
R3_14 M6:GATE A:20 7.57576
R3_15 M6:GATE A:19 7.57576
R3_16 M7:GATE A:15 7.57576
R3_17 M7:GATE A:14 7.57576
R3_18 M8:GATE A:11 7.57576
R3_19 M8:GATE A:10 7.57576
R3_20 A:10 A:38 5.55556
R3_21 A:11 A:31 10.6061
R3_22 A:12 A:31 10.6061
R3_23 A:14 A:39 5.55556
R3_24 A:15 A:33 10.6061
R3_25 A:16 A:33 10.6061
R3_26 A:17 A:18 5.55556
R3_27 A:19 A:40 5.55556
R3_28 A:20 A:29 10.6061
R3_29 A:21 A:29 10.6061
R3_30 A:22 A:23 5.55556
R3_31 A:24 A:41 5.55556
R3_32 A:25 A:42 10.6061
R3_33 A:26 A:42 10.6061
R3_34 A:27 A:28 5.55556
R3_35 A:29 A:35 27.7339
R3_36 A:30 A:31 63.5281
R3_37 A:30 A:32 25.0832
R3_38 A:32 A:33 63.5281
R3_39 A:32 A:34 37.6249
R3_40 A:34 A:35 63.5281
R3_41 A:34 A:36 3.58332
R3_42 A:35 A:42 27.7339

*|NET Y 7.01055e-05PF
*|P (Y B 0 0.3570 0.0720)
*|I (M1:SRC M1 SRC B 0 0.3300 0.0360)
*|I (M10:DRN M10 DRN B 0 0.3000 0.1080)
*|I (M11:SRC M11 SRC B 0 0.2460 0.1080)
*|I (M12:DRN M12 DRN B 0 0.2160 0.1080)
*|I (M2:DRN M2 DRN B 0 0.3000 0.0360)
*|I (M3:SRC M3 SRC B 0 0.2460 0.0360)
*|I (M4:DRN M4 DRN B 0 0.2160 0.0360)
*|I (M9:SRC M9 SRC B 0 0.3300 0.1080)
C4_1 M4:DRN VSS:12 2.82443e-20
C4_2 Y:26 VSS:12 6.05689e-20
C4_3 M2:DRN VSS:13 3.18486e-20
C4_4 Y:26 VSS:13 1.31178e-19
C4_5 Y:26 VSS:14 2.81845e-19
C4_6 M2:DRN VSS:20 2.08949e-20
C4_7 M4:DRN VSS:20 2.09115e-20
C4_8 Y:10 VSS:20 2.32212e-18
C4_9 Y:12 VSS:20 2.31904e-18
C4_10 Y:26 VSS:20 1.33978e-18
C4_11 Y:27 VSS:20 1.39075e-19
C4_12 Y:10 VSS:24 3.37061e-20
C4_13 Y:14 VSS:24 3.18486e-20
C4_14 Y:26 VSS:24 5.26818e-20
C4_15 Y:12 VSS:25 4.41381e-20
C4_16 Y:16 VSS:25 3.18486e-20
C4_17 Y:26 VSS:25 6.37557e-20
C4_18 Y:10 VSS:26 9.72769e-20
C4_19 Y:12 VSS:26 6.75866e-20
C4_20 Y:26 VSS:26 9.75321e-18
C4_21 Y:27 VSS:26 3.56549e-20
C4_22 M2:DRN VSS:27 1.38606e-19
C4_23 Y:26 VSS:27 8.09428e-19
C4_24 M4:DRN VSS:28 2.13821e-20
C4_25 Y:26 VSS:28 6.53731e-20
C4_26 M12:DRN VDD:12 2.82443e-20
C4_27 Y:27 VDD:12 6.02467e-20
C4_28 M10:DRN VDD:13 3.18808e-20
C4_29 Y:27 VDD:13 1.30987e-19
C4_30 Y:26 VDD:14 1.7586e-19
C4_31 Y:27 VDD:14 1.07057e-19
C4_32 Y:11 VDD:20 1.19561e-18
C4_33 Y:13 VDD:20 1.19561e-18
C4_34 Y:26 VDD:20 2.09138e-19
C4_35 Y:27 VDD:20 3.57428e-19
C4_36 Y:11 VDD:24 2.80634e-20
C4_37 Y:15 VDD:24 3.18808e-20
C4_38 Y:27 VDD:24 5.26983e-20
C4_39 Y:13 VDD:25 4.41973e-20
C4_40 Y:17 VDD:25 3.18808e-20
C4_41 Y:26 VDD:25 2.28626e-20
C4_42 Y:27 VDD:25 4.10334e-20
C4_43 Y:11 VDD:26 2.10608e-19
C4_44 Y:13 VDD:26 1.80995e-19
C4_45 Y:26 VDD:26 1.11432e-19
C4_46 Y:27 VDD:26 9.70072e-18
C4_47 M10:DRN VDD:27 4.95842e-20
C4_48 Y:27 VDD:27 7.9099e-19
C4_49 M12:DRN VDD:28 2.13821e-20
C4_50 Y:27 VDD:28 6.53731e-20
Cg4_51 Y:10 VSS 4.04337e-19
Cg4_52 Y:11 VSS 3.60318e-19
Cg4_53 Y:12 VSS 3.06377e-19
Cg4_54 Y:13 VSS 2.97398e-19
Cg4_55 Y:14 VSS 2.67377e-19
Cg4_56 Y:15 VSS 2.67634e-19
Cg4_57 Y:16 VSS 2.20595e-19
Cg4_58 Y:17 VSS 2.20434e-19
Cg4_59 Y:26 VSS 4.59256e-18
Cg4_60 Y:27 VSS 2.23872e-18
R4_1 Y Y:27 25.8596
R4_2 Y Y:26 25.7999
R4_3 M1:SRC Y:16 30000.0
R4_4 M1:SRC Y:30 20270.3
R4_5 M1:SRC Y:12 57692.3
R4_6 M1:SRC Y:23 30000.0
R4_7 M10:DRN Y:13 30000.0
R4_8 M10:DRN Y:31 20089.3
R4_9 M10:DRN Y:17 59210.5
R4_10 M10:DRN Y:25 30000.0
R4_11 M11:SRC Y:11 30000.0
R4_12 M11:SRC Y:29 20089.3
R4_13 M11:SRC Y:15 59210.5
R4_14 M11:SRC Y:21 30000.0
R4_15 M12:DRN Y:11 30000.0
R4_16 M12:DRN Y:29 20089.3
R4_17 M12:DRN Y:15 59210.5
R4_18 M12:DRN Y:21 30000.0
R4_19 M2:DRN Y:16 30000.0
R4_20 M2:DRN Y:30 20270.3
R4_21 M2:DRN Y:12 57692.3
R4_22 M2:DRN Y:23 30000.0
R4_23 M3:SRC Y:14 30000.0
R4_24 M3:SRC Y:28 20270.3
R4_25 M3:SRC Y:10 57692.3
R4_26 M3:SRC Y:19 30000.0
R4_27 M4:DRN Y:14 30000.0
R4_28 M4:DRN Y:28 20270.3
R4_29 M4:DRN Y:10 57692.3
R4_30 M4:DRN Y:19 30000.0
R4_31 M9:SRC Y:13 30000.0
R4_32 M9:SRC Y:31 20089.3
R4_33 M9:SRC Y:17 59210.5
R4_34 M9:SRC Y:25 30000.0
R4_35 Y:10 Y:19 5.51634
R4_36 Y:11 Y:21 14.1199
R4_37 Y:11 Y:29 8.62446
R4_38 Y:12 Y:23 5.51634
R4_39 Y:13 Y:25 14.1199
R4_40 Y:13 Y:31 8.62446
R4_41 Y:14 Y:19 14.0605
R4_42 Y:14 Y:28 49500.0
R4_43 Y:15 Y:21 5.45702
R4_44 Y:16 Y:23 14.0605
R4_45 Y:16 Y:30 49500.0
R4_46 Y:17 Y:25 5.45702
R4_47 Y:18 Y:19 63.5281
R4_48 Y:18 Y:32 3.58332
R4_49 Y:18 Y:22 50.1665
R4_50 Y:19 Y:28 3.7634
R4_51 Y:20 Y:21 63.5281
R4_52 Y:20 Y:33 3.58332
R4_53 Y:20 Y:24 50.1665
R4_54 Y:21 Y:29 21900.0
R4_55 Y:22 Y:23 63.5281
R4_56 Y:22 Y:26 25.0832
R4_57 Y:23 Y:30 3.7634
R4_58 Y:24 Y:25 63.5281
R4_59 Y:24 Y:27 25.0832
R4_60 Y:25 Y:31 21900.0

*|NET 5 0.000106316PF
*|I (M1:GATE M1 GATE I 3.6e-19 0.3360 0.0360)
*|I (M10:GATE M10 GATE I 3.6e-19 0.2940 0.1080)
*|I (M11:GATE M11 GATE I 3.6e-19 0.2520 0.1080)
*|I (M12:GATE M12 GATE I 3.6e-19 0.2100 0.1080)
*|I (M13:SRC M13 SRC B 0 0.1620 0.1080)
*|I (M14:DRN M14 DRN B 0 0.1320 0.1080)
*|I (M15:SRC M15 SRC B 0 0.0780 0.1080)
*|I (M16:DRN M16 DRN B 0 0.0480 0.1080)
*|I (M2:GATE M2 GATE I 3.6e-19 0.2940 0.0360)
*|I (M3:GATE M3 GATE I 3.6e-19 0.2520 0.0360)
*|I (M4:GATE M4 GATE I 3.6e-19 0.2100 0.0360)
*|I (M5:SRC M5 SRC B 0 0.1620 0.0360)
*|I (M6:DRN M6 DRN B 0 0.1320 0.0360)
*|I (M7:SRC M7 SRC B 0 0.0780 0.0360)
*|I (M8:DRN M8 DRN B 0 0.0480 0.0360)
*|I (M9:GATE M9 GATE I 3.6e-19 0.3360 0.1080)
C6_1 M8:DRN VSS:10 2.82443e-20
C6_2 5:59 VSS:10 6.05689e-20
C6_3 M6:DRN VSS:11 3.18486e-20
C6_4 5:59 VSS:11 2.05261e-19
C6_5 5:59 VSS:12 1.32169e-19
C6_6 5:61 VSS:12 1.82514e-19
C6_7 5:27 VSS:13 1.23247e-18
C6_8 M6:DRN VSS:20 2.08949e-20
C6_9 M8:DRN VSS:20 2.09119e-20
C6_10 5:17 VSS:20 4.60642e-19
C6_11 5:18 VSS:20 7.89427e-21
C6_12 5:21 VSS:20 4.59524e-19
C6_13 5:22 VSS:20 7.89427e-21
C6_14 5:26 VSS:20 4.60197e-19
C6_15 5:27 VSS:20 7.89427e-21
C6_16 5:31 VSS:20 4.68614e-19
C6_17 5:32 VSS:20 7.89427e-21
C6_18 5:36 VSS:20 2.3222e-18
C6_19 5:38 VSS:20 2.31904e-18
C6_20 5:59 VSS:20 4.83685e-19
C6_21 5:62 VSS:20 2.22114e-20
C6_22 5:36 VSS:22 2.80042e-20
C6_23 5:41 VSS:22 3.18486e-20
C6_24 5:59 VSS:22 5.26818e-20
C6_25 5:38 VSS:23 4.41381e-20
C6_26 5:43 VSS:23 3.18486e-20
C6_27 5:59 VSS:23 4.32252e-20
C6_28 5:61 VSS:23 2.27223e-20
C6_29 5:17 VSS:26 3.98637e-22
C6_30 5:21 VSS:26 2.5889e-20
C6_31 5:26 VSS:26 3.51888e-20
C6_32 5:31 VSS:26 2.5889e-20
C6_33 5:36 VSS:26 1.53755e-19
C6_34 5:38 VSS:26 1.24028e-19
C6_35 5:59 VSS:26 9.61247e-18
C6_36 5:60 VSS:26 3.91254e-20
C6_37 5:61 VSS:26 5.05808e-20
C6_38 5:62 VSS:26 9.35252e-19
C6_39 5:21 VSS:27 1.02173e-19
C6_40 5:27 VSS:27 6.91052e-19
C6_41 5:28 VSS:27 1.87735e-19
C6_42 5:31 VSS:27 1.94396e-20
C6_43 5:62 VSS:27 3.06792e-19
C6_44 5:59 VSS:28 1.40057e-19
C6_45 5:61 VSS:28 3.91709e-19
C6_46 5:62 VSS:28 2.41841e-19
C6_47 M6:DRN VSS:29 2.80042e-20
C6_48 5:59 VSS:29 3.89157e-19
C6_49 M8:DRN VSS:30 2.13821e-20
C6_50 5:59 VSS:30 6.53731e-20
C6_51 M16:DRN VDD:10 2.82443e-20
C6_52 5:60 VDD:10 6.02467e-20
C6_53 M14:DRN VDD:11 3.18808e-20
C6_54 5:60 VDD:11 2.05121e-19
C6_55 5:60 VDD:12 1.32155e-19
C6_56 5:61 VDD:12 1.83724e-19
C6_57 5:29 VDD:13 1.23268e-18
C6_58 5:20 VDD:20 1.14913e-19
C6_59 5:25 VDD:20 1.15217e-19
C6_60 5:30 VDD:20 1.15891e-19
C6_61 5:35 VDD:20 1.24307e-19
C6_62 5:37 VDD:20 1.19561e-18
C6_63 5:39 VDD:20 1.19561e-18
C6_64 5:37 VDD:22 2.80634e-20
C6_65 5:42 VDD:22 3.18808e-20
C6_66 5:60 VDD:22 5.26983e-20
C6_67 5:39 VDD:23 4.41973e-20
C6_68 5:44 VDD:23 3.18808e-20
C6_69 5:60 VDD:23 4.32396e-20
C6_70 5:61 VDD:23 2.28626e-20
C6_71 5:20 VDD:26 3.47119e-20
C6_72 5:25 VDD:26 4.17741e-20
C6_73 5:30 VDD:26 7.69213e-20
C6_74 5:35 VDD:26 6.76391e-20
C6_75 5:37 VDD:26 2.66928e-19
C6_76 5:39 VDD:26 2.37278e-19
C6_77 5:59 VDD:26 3.91599e-20
C6_78 5:60 VDD:26 9.66368e-18
C6_79 5:61 VDD:26 5.06959e-20
C6_80 5:62 VDD:26 9.39903e-19
C6_81 5:28 VDD:27 1.87735e-19
C6_82 5:29 VDD:27 6.91121e-19
C6_83 5:30 VDD:27 2.55697e-19
C6_84 5:35 VDD:27 3.93596e-22
C6_85 5:62 VDD:27 6.63905e-20
C6_86 5:60 VDD:28 1.40057e-19
C6_87 5:61 VDD:28 2.06442e-19
C6_88 5:62 VDD:28 9.9272e-21
C6_89 M14:DRN VDD:29 2.80634e-20
C6_90 5:60 VDD:29 3.89165e-19
C6_91 M16:DRN VDD:30 2.13821e-20
C6_92 5:60 VDD:30 6.53731e-20
C6_93 5:59 A 9.49071e-19
C6_94 5:61 A 2.88844e-19
C6_95 5:59 A:14 3.33633e-20
C6_96 5:59 A:15 8.76011e-20
C6_97 5:60 A:17 8.76295e-20
C6_98 5:60 A:18 2.44658e-20
C6_99 5:59 A:19 2.82147e-20
C6_100 5:59 A:20 6.1289e-20
C6_101 5:60 A:22 6.13044e-20
C6_102 5:60 A:23 1.9335e-20
C6_103 5:59 A:24 2.82147e-20
C6_104 5:59 A:25 7.384e-20
C6_105 5:60 A:27 7.38289e-20
C6_106 5:60 A:28 1.9335e-20
C6_107 M14:DRN A:29 2.09115e-20
C6_108 5:38 A:29 1.17406e-18
C6_109 5:39 A:29 2.33954e-18
C6_110 5:60 A:29 1.16953e-19
C6_111 5:62 A:29 1.85173e-19
C6_112 5:60 A:33 2.61448e-20
C6_113 5:36 A:36 3.01231e-19
C6_114 5:37 A:36 5.96909e-20
C6_115 5:38 A:36 2.94798e-19
C6_116 5:39 A:36 1.3238e-19
C6_117 5:59 A:36 3.94049e-18
C6_118 5:60 A:36 3.92952e-18
C6_119 5:61 A:36 2.37843e-19
C6_120 5:62 A:36 5.19214e-19
C6_121 5:60 A:37 9.85772e-19
C6_122 5:61 A:37 2.97729e-19
C6_123 5:40 M10:DRN 2.09115e-20
C6_124 5:22 Y:10 6.91052e-19
C6_125 5:23 Y:10 1.87735e-19
C6_126 5:62 Y:10 3.01207e-19
C6_127 5:23 Y:11 1.87735e-19
C6_128 5:62 Y:11 5.96672e-20
C6_129 5:31 Y:12 1.82222e-19
C6_130 5:32 Y:12 6.85177e-19
C6_131 5:33 Y:12 1.83539e-19
C6_132 5:40 Y:12 1.17406e-18
C6_133 5:62 Y:12 3.60309e-19
C6_134 5:33 Y:13 1.83539e-19
C6_135 5:34 Y:13 6.85193e-19
C6_136 5:35 Y:13 1.82222e-19
C6_137 5:40 Y:13 2.33954e-18
C6_138 5:62 Y:13 1.98023e-19
C6_139 5:22 Y:14 1.23547e-18
C6_140 5:32 Y:16 1.22701e-18
C6_141 5:34 Y:17 1.22717e-18
C6_142 5:21 Y:26 9.96357e-21
C6_143 5:22 Y:26 6.31209e-20
C6_144 5:23 Y:26 7.31977e-20
C6_145 5:27 Y:26 6.35307e-20
C6_146 5:28 Y:26 1.16874e-19
C6_147 5:32 Y:26 1.7391e-19
C6_148 5:33 Y:26 2.36738e-19
C6_149 5:34 Y:26 1.15752e-19
C6_150 5:40 Y:26 2.14361e-19
C6_151 5:59 Y:26 1.05653e-18
C6_152 5:61 Y:26 6.68398e-19
C6_153 5:62 Y:26 4.72042e-18
C6_154 5:23 Y:27 3.54683e-20
C6_155 5:24 Y:27 4.75517e-20
C6_156 5:25 Y:27 1.9335e-20
C6_157 5:28 Y:27 7.32791e-20
C6_158 5:29 Y:27 6.52004e-20
C6_159 5:30 Y:27 3.14075e-20
C6_160 5:34 Y:27 5.88993e-20
C6_161 5:40 Y:27 1.16953e-19
C6_162 5:48 Y:27 2.61448e-20
C6_163 5:60 Y:27 1.05653e-18
C6_164 5:61 Y:27 1.07999e-19
C6_165 5:62 Y:27 3.87943e-18
Cg6_166 5:17 VSS 1.08842e-19
Cg6_167 5:19 VSS 3.4119e-19
Cg6_168 5:20 VSS 2.25021e-19
Cg6_169 5:21 VSS 2.08947e-19
Cg6_170 5:23 VSS 3.4119e-19
Cg6_171 5:25 VSS 2.27134e-19
Cg6_172 5:26 VSS 1.00471e-19
Cg6_173 5:28 VSS 5.60298e-19
Cg6_174 5:30 VSS 2.38246e-19
Cg6_175 5:31 VSS 9.99012e-20
Cg6_176 5:33 VSS 9.8281e-19
Cg6_177 5:35 VSS 2.37676e-19
Cg6_178 5:36 VSS 4.11852e-19
Cg6_179 5:37 VSS 3.60318e-19
Cg6_180 5:38 VSS 3.06377e-19
Cg6_181 5:39 VSS 2.97398e-19
Cg6_182 5:40 VSS 6.27253e-19
Cg6_183 5:41 VSS 2.67377e-19
Cg6_184 5:42 VSS 2.67634e-19
Cg6_185 5:43 VSS 2.20595e-19
Cg6_186 5:44 VSS 2.20434e-19
Cg6_187 5:46 VSS 7.88992e-20
Cg6_188 5:48 VSS 7.39304e-20
Cg6_189 5:59 VSS 1.95058e-18
Cg6_190 5:60 VSS 1.95062e-18
Cg6_191 5:61 VSS 1.30316e-18
Cg6_192 5:62 VSS 1.77925e-18
R6_1 M1:GATE 5:32 7.57576
R6_2 M1:GATE 5:31 7.57576
R6_3 M10:GATE 5:29 7.57576
R6_4 M10:GATE 5:28 7.57576
R6_5 M11:GATE 5:24 7.57576
R6_6 M11:GATE 5:23 7.57576
R6_7 M12:GATE 5:20 13.1313
R6_8 M12:GATE 5:19 7.57576
R6_9 M13:SRC 5:39 30000.0
R6_10 M13:SRC 5:71 20089.3
R6_11 M13:SRC 5:44 59210.5
R6_12 M13:SRC 5:58 30000.0
R6_13 M14:DRN 5:39 30000.0
R6_14 M14:DRN 5:71 20089.3
R6_15 M14:DRN 5:44 59210.5
R6_16 M14:DRN 5:58 30000.0
R6_17 M15:SRC 5:37 30000.0
R6_18 M15:SRC 5:69 20089.3
R6_19 M15:SRC 5:42 59210.5
R6_20 M15:SRC 5:54 30000.0
R6_21 M16:DRN 5:37 30000.0
R6_22 M16:DRN 5:69 20089.3
R6_23 M16:DRN 5:42 59210.5
R6_24 M16:DRN 5:54 30000.0
R6_25 M2:GATE 5:27 7.57576
R6_26 M2:GATE 5:26 7.57576
R6_27 M3:GATE 5:22 7.57576
R6_28 M3:GATE 5:21 7.57576
R6_29 M4:GATE 5:18 7.57576
R6_30 M4:GATE 5:17 7.57576
R6_31 M5:SRC 5:43 30000.0
R6_32 M5:SRC 5:70 20270.3
R6_33 M5:SRC 5:38 57692.3
R6_34 M5:SRC 5:56 30000.0
R6_35 M6:DRN 5:43 30000.0
R6_36 M6:DRN 5:70 20270.3
R6_37 M6:DRN 5:38 57692.3
R6_38 M6:DRN 5:56 30000.0
R6_39 M7:SRC 5:41 30000.0
R6_40 M7:SRC 5:68 20270.3
R6_41 M7:SRC 5:36 57692.3
R6_42 M7:SRC 5:52 30000.0
R6_43 M8:DRN 5:41 30000.0
R6_44 M8:DRN 5:68 20270.3
R6_45 M8:DRN 5:36 57692.3
R6_46 M8:DRN 5:52 30000.0
R6_47 M9:GATE 5:34 7.57576
R6_48 M9:GATE 5:33 7.57576
R6_49 5:17 5:63 5.55556
R6_50 5:18 5:46 10.6061
R6_51 5:19 5:46 10.6061
R6_52 5:21 5:64 5.55556
R6_53 5:22 5:48 10.6061
R6_54 5:23 5:48 10.6061
R6_55 5:24 5:25 5.55556
R6_56 5:26 5:65 5.55556
R6_57 5:27 5:40 10.6061
R6_58 5:28 5:40 10.6061
R6_59 5:29 5:30 5.55556
R6_60 5:31 5:66 5.55556
R6_61 5:32 5:67 10.6061
R6_62 5:33 5:67 10.6061
R6_63 5:34 5:35 5.55556
R6_64 5:36 5:52 5.51634
R6_65 5:37 5:54 14.1199
R6_66 5:37 5:69 8.62446
R6_67 5:38 5:56 5.51634
R6_68 5:39 5:58 14.1199
R6_69 5:39 5:71 8.62446
R6_70 5:40 5:50 27.7339
R6_71 5:41 5:52 14.0605
R6_72 5:41 5:68 49500.0
R6_73 5:42 5:54 5.45702
R6_74 5:43 5:56 14.0605
R6_75 5:43 5:70 49500.0
R6_76 5:44 5:58 5.45702
R6_77 5:45 5:46 63.5281
R6_78 5:45 5:61 12.5416
R6_79 5:45 5:47 25.0832
R6_80 5:47 5:48 63.5281
R6_81 5:47 5:49 37.6249
R6_82 5:49 5:50 63.5281
R6_83 5:49 5:62 3.58332
R6_84 5:50 5:67 27.7339
R6_85 5:51 5:52 63.5281
R6_86 5:51 5:72 3.58332
R6_87 5:51 5:55 50.1665
R6_88 5:52 5:68 3.7634
R6_89 5:53 5:54 63.5281
R6_90 5:53 5:73 3.58332
R6_91 5:53 5:57 50.1665
R6_92 5:54 5:69 21900.0
R6_93 5:55 5:56 63.5281
R6_94 5:55 5:59 25.0832
R6_95 5:56 5:70 3.7634
R6_96 5:57 5:58 63.5281
R6_97 5:57 5:60 25.0832
R6_98 5:58 5:71 21900.0
R6_99 5:59 5:61 25.7999
R6_100 5:60 5:61 25.8596

*|NET 7 8.53777e-05PF
C7_1 7:1 VSS:10 8.03136e-19
C7_2 7:1 VSS:11 8.03382e-19
C7_3 7:1 VSS:12 8.03136e-19
C7_4 7:1 VSS:20 6.62137e-20
C7_5 7:3 VSS:20 1.35956e-19
C7_6 7:1 VSS:26 1.18348e-18
C7_7 7:2 VSS:26 5.91211e-19
C7_8 7:3 VSS:26 3.20198e-20
C7_9 7:1 VSS:28 1.50136e-18
C7_10 7:1 VSS:29 1.50868e-18
C7_11 7:1 VSS:30 1.50136e-18
C7_12 7:1 VDD:10 8.0314e-19
C7_13 7:1 VDD:11 8.03418e-19
C7_14 7:1 VDD:12 8.0314e-19
C7_15 7:1 VDD:26 1.88299e-18
C7_16 7:1 VDD:27 3.47913e-19
C7_17 7:1 VDD:28 1.50126e-18
C7_18 7:1 VDD:29 1.50862e-18
C7_19 7:1 VDD:30 1.50126e-18
C7_20 7:1 A 4.74272e-19
C7_21 7:1 A:36 4.01357e-19
C7_22 7:1 A:37 4.03915e-19
C7_23 7:1 Y:10 1.0432e-20
C7_24 7:2 Y:10 1.80413e-19
C7_25 7:1 Y:11 8.89477e-19
C7_26 7:1 Y:15 8.03418e-19
C7_27 7:1 Y:26 8.68994e-19
C7_28 7:2 Y:26 1.80073e-19
C7_29 7:3 Y:26 1.55906e-19
C7_30 7:1 Y:27 6.80519e-19
C7_31 7:1 5:36 1.07714e-18
C7_32 7:1 5:37 1.07721e-18
C7_33 7:1 5:38 1.05094e-18
C7_34 7:1 5:39 1.05095e-18
C7_35 7:1 5:40 5.41347e-21
C7_36 7:1 5:41 8.03382e-19
C7_37 7:1 5:42 8.03418e-19
C7_38 7:1 5:43 7.999e-19
C7_39 7:1 5:44 7.99905e-19
C7_40 7:1 5:59 7.27697e-19
C7_41 7:1 5:60 7.27623e-19
C7_42 7:1 5:61 6.57142e-19
C7_43 7:1 5:62 4.52981e-19
Cg7_44 7:1 VSS 4.70196e-17
Cg7_45 7:2 VSS 3.96707e-18
R7_1 7:1 7:2 10289.6
R7_2 7:2 7:3 1326.22

*|NET 8 0PF
R8_1 8:1 8:2 74455.2

*|NET _generated_10 3.08088e-06PF
C9_1 _generated_10:1 VSS:20 1.47021e-19
C9_2 _generated_10:1 VDD:20 1.18927e-19
C9_3 _generated_10:1 VDD:26 4.89892e-20
C9_4 _generated_10:1 VDD:30 3.74453e-19
C9_5 _generated_10:1 A:37 3.15962e-19
C9_6 _generated_10:1 7:1 5.65589e-19
Cg9_7 _generated_10:1 VSS 9.3089e-19
R9_1 _generated_10:1 _generated_10:2 28.2828

*|NET _generated_11 5.37479e-06PF
C10_1 _generated_11:1 VSS:20 9.21148e-19
C10_2 _generated_11:1 VSS:26 9.68154e-20
C10_3 _generated_11:1 5:28 7.90108e-21
C10_4 _generated_11:1 5:31 1.58022e-21
C10_5 _generated_11:1 5:33 2.39886e-19
Cg10_6 _generated_11:1 VSS 3.50331e-18
R10_1 _generated_11:1 _generated_11:2 28.2828

*|NET _generated_12 5.0073e-06PF
C11_1 _generated_12:1 VDD:20 5.78695e-19
C11_2 _generated_12:1 VDD:26 1.91825e-19
C11_3 _generated_12:1 5:28 7.90108e-21
C11_4 _generated_12:1 5:33 2.39886e-19
C11_5 _generated_12:1 5:35 1.58022e-21
C11_6 _generated_12:1 _generated_11:1 6.0415e-19
Cg11_7 _generated_12:1 VSS 3.38326e-18
R11_1 _generated_12:1 _generated_12:2 28.2828

*|NET _generated_9 2.86348e-06PF
C12_1 _generated_9:1 VSS:26 2.25577e-20
C12_2 _generated_9:1 VSS:30 3.44976e-19
C12_3 _generated_9:1 A 3.06042e-19
C12_4 _generated_9:1 7:1 6.61239e-19
C12_5 _generated_9:1 _generated_10:1 5.79044e-19
Cg12_6 _generated_9:1 VSS 9.49624e-19
R12_1 _generated_9:1 _generated_9:2 28.2828

*
* Instance Section
*
MM1 M1:DRN M1:GATE M1:SRC VSS NMOS_LVT l=0.012u w=0.03u NF=1
MM10 M10:DRN M10:GATE M10:SRC VDD PMOS_LVT l=0.012u w=0.03u NF=1
MM11 M11:DRN M11:GATE M11:SRC VDD PMOS_LVT l=0.012u w=0.03u NF=1
MM12 M12:DRN M12:GATE M12:SRC VDD PMOS_LVT l=0.012u w=0.03u NF=1
MM13 M13:DRN M13:GATE M13:SRC VDD PMOS_LVT l=0.012u w=0.03u NF=1
MM14 M14:DRN M14:GATE M14:SRC VDD PMOS_LVT l=0.012u w=0.03u NF=1
MM15 M15:DRN M15:GATE M15:SRC VDD PMOS_LVT l=0.012u w=0.03u NF=1
MM16 M16:DRN M16:GATE M16:SRC VDD PMOS_LVT l=0.012u w=0.03u NF=1
MM2 M2:DRN M2:GATE M2:SRC VSS NMOS_LVT l=0.012u w=0.03u NF=1
MM3 M3:DRN M3:GATE M3:SRC VSS NMOS_LVT l=0.012u w=0.03u NF=1
MM4 M4:DRN M4:GATE M4:SRC VSS NMOS_LVT l=0.012u w=0.03u NF=1
MM5 M5:DRN M5:GATE M5:SRC VSS NMOS_LVT l=0.012u w=0.03u NF=1
MM6 M6:DRN M6:GATE M6:SRC VSS NMOS_LVT l=0.012u w=0.03u NF=1
MM7 M7:DRN M7:GATE M7:SRC VSS NMOS_LVT l=0.012u w=0.03u NF=1
MM8 M8:DRN M8:GATE M8:SRC VSS NMOS_LVT l=0.012u w=0.03u NF=1
MM9 M9:DRN M9:GATE M9:SRC VDD PMOS_LVT l=0.012u w=0.03u NF=1

.ENDS
