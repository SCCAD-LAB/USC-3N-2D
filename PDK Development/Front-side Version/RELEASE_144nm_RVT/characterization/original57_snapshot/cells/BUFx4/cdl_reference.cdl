* CANDIDATE independent circuit from preserved2024 prior-layout DSPF.
* All resistive segments collapsed to ideal wires; capacitors omitted for LVS topology.
* Not extracted from the new144nmDUT. Requires independent review before gold admission.
* Source /cedar/cedar_coe/ece-limsk/sw.jung/pdk/LIB_issue_fix/final_w17_pdk/1_fspr/10_liberate_final_fspr_rvt/NETLIST/BUFx4.spf
.SUBCKT BUFx4 A VDD VSS Y
MMM9 Y MM0:DRN VSS nmos_rvt l=0.012u w=0.03u
MMM6 Y MM0:DRN VDD pmos_rvt l=0.012u w=0.03u
MMM5 Y MM0:DRN VDD pmos_rvt l=0.012u w=0.03u
MMM2 Y MM0:DRN VDD pmos_rvt l=0.012u w=0.03u
MMM14 MM0:DRN A VDD pmos_rvt l=0.012u w=0.03u
MMM13 MM0:DRN A VDD pmos_rvt l=0.012u w=0.03u
MMM10 MM0:DRN A VDD pmos_rvt l=0.012u w=0.03u
MMM1 MM0:DRN A VDD pmos_rvt l=0.012u w=0.03u
MMM7 Y MM0:DRN VSS nmos_rvt l=0.012u w=0.03u
MMM4 Y MM0:DRN VSS nmos_rvt l=0.012u w=0.03u
MMM3 Y MM0:DRN VSS nmos_rvt l=0.012u w=0.03u
MMM15 MM0:DRN A VSS nmos_rvt l=0.012u w=0.03u
MMM12 MM0:DRN A VSS nmos_rvt l=0.012u w=0.03u
MMM11 MM0:DRN A VSS nmos_rvt l=0.012u w=0.03u
MMM0 MM0:DRN A VSS nmos_rvt l=0.012u w=0.03u
MMM8 Y MM0:DRN VDD pmos_rvt l=0.012u w=0.03u
.ends BUFx4
