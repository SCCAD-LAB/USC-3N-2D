* CANDIDATE independent circuit from preserved2024 prior-layout DSPF.
* All resistive segments collapsed to ideal wires; capacitors omitted for LVS topology.
* Not extracted from the new144nmDUT. Requires independent review before gold admission.
* Source /cedar/cedar_coe/ece-limsk/sw.jung/pdk/LIB_issue_fix/final_w17_pdk/1_fspr/10_liberate_final_fspr_rvt/NETLIST/DFFHx1.spf
.SUBCKT DFFHx1 CK D QN RESET SET VDD VSS
MMM40 QN MM27:SRC VSS nmos_rvt l=0.012u w=0.03u
MMM29 MM24:SRC RESET VSS nmos_rvt l=0.012u w=0.015u
MMM25 MM24:SRC MM19:DRN VSS nmos_rvt l=0.012u w=0.015u
MMM24 MH:10 MM13:DRN MM24:SRC nmos_rvt l=0.012u w=0.015u
MMM15 MH:10 MM11:DRN MM15:SRC nmos_rvt l=0.012u w=0.03u
MMM18 MM15:SRC D VSS nmos_rvt l=0.012u w=0.03u
MMM13 MM13:DRN MM11:DRN VSS nmos_rvt l=0.012u w=0.03u
MMM12 MM11:DRN CK VSS nmos_rvt l=0.012u w=0.03u
MMM39 QN MM27:SRC VDD pmos_rvt l=0.012u w=0.03u
MMM37 MM27:SRC MM13:DRN MM36:DRN pmos_rvt l=0.012u w=0.015u
MMM36 MM36:DRN MM30:DRN MM36:SRC pmos_rvt l=0.012u w=0.015u
MMM35 MM27:SRC MM11:DRN MM33:DRN nmos_rvt l=0.012u w=0.015u
MMM38 MM36:SRC SET VDD pmos_rvt l=0.012u w=0.015u
MMM28 MM28:DRN RESET VDD pmos_rvt l=0.012u w=0.015u
MMM5 MM30:DRN MM27:SRC MM28:DRN pmos_rvt l=0.012u w=0.015u
MMM27 MM19:DRN MM11:DRN MM27:SRC pmos_rvt l=0.012u w=0.015u
MMM19 MM19:DRN MH:10 MM19:SRC pmos_rvt l=0.012u w=0.015u
MMM1 MM19:SRC SET VDD pmos_rvt l=0.012u w=0.015u
MMM22 MM21:SRC RESET VDD pmos_rvt l=0.012u w=0.015u
MMM21 MM21:DRN MM19:DRN MM21:SRC pmos_rvt l=0.012u w=0.015u
MMM23 MH:10 MM11:DRN MM21:DRN pmos_rvt l=0.012u w=0.015u
MMM16 MH:10 MM13:DRN MM16:SRC pmos_rvt l=0.012u w=0.03u
MMM33 MM33:DRN MM30:DRN VSS nmos_rvt l=0.012u w=0.015u
MMM17 MM16:SRC D VDD pmos_rvt l=0.012u w=0.03u
MMM14 MM13:DRN MM11:DRN VDD pmos_rvt l=0.012u w=0.03u
MMM11 MM11:DRN CK VDD pmos_rvt l=0.012u w=0.03u
MMM34 MM33:DRN SET VSS nmos_rvt l=0.012u w=0.015u
MMM31 MM30:DRN RESET VSS nmos_rvt l=0.012u w=0.015u
MMM30 MM30:DRN MM27:SRC VSS nmos_rvt l=0.012u w=0.015u
MMM26 MM19:DRN MM13:DRN MM27:SRC nmos_rvt l=0.012u w=0.014u
MMM20 MM19:DRN MH:10 VSS nmos_rvt l=0.012u w=0.015u
MMM32 MM19:DRN SET VSS nmos_rvt l=0.012u w=0.015u
.ends DFFHx1
