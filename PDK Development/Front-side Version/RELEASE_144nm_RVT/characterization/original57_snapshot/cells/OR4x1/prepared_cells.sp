*
*|DSPF 1.3
*|DESIGN OR4x1
*|DATE "Tue Nov  3 20:54:33 2026"
*|VENDOR "Synopsys"
*|PROGRAM "StarRC"
*|VERSION "X-2025.06-SP1"
*|DIVIDER /
*|DELIMITER :
**FORMAT SPF
*

** COMMENTS

** OPERATING_TEMPERATURE 25
** GLOBAL_TEMPERATURE 25
**
** TCAD_GRD_FILE /cedar/cedar_coe/ece-limsk/yhuang861/GRO/.planning/experiments_migrated_20261022/usc144_github_release_20261103/sources/github_FSPR.nxtgrd
**   TCAD_TIME_STAMP Tue Mar 31 05:07:55 2026
**   TCADGRD_VERSION 89

.SUBCKT OR4x1 VSS VDD Y A B C D

*|GROUND_NET VSS

*|NET VSS 0.000110159PF
*|P (VSS B 0 0.1470 0.0000)
*|I (M1:SRC M1 SRC B 0 0.2460 0.0360)
*|I (M2:DRN M2 DRN B 0 0.1740 0.0360)
*|I (M3:SRC M3 SRC B 0 0.1200 0.0360)
*|I (M4:DRN M4 DRN B 0 0.0900 0.0360)
*|I (M5:SRC M5 SRC B 0 0.0360 0.0360)
Cg1_1 VSS:7 VSS 2.60582e-19
Cg1_2 VSS:8 VSS 2.65379e-19
Cg1_3 VSS:9 VSS 1.78742e-19
Cg1_4 VSS:10 VSS 1.90317e-19
Cg1_5 VSS:18 VSS 2.94482e-18
Cg1_6 VSS:21 VSS 3.96184e-17
Cg1_7 VSS:26 VSS 4.59594e-18
Cg1_8 VSS:28 VSS 9.01322e-18
Cg1_9 VSS:29 VSS 6.45212e-19
Cg1_10 VSS:30 VSS 4.68667e-19
Cg1_11 VSS:31 VSS 5.32932e-19
R1_1 VSS VSS:14 25.0832
R1_2 VSS VSS:16 25.0832
R1_3 VSS VSS:15 63.5281
R1_4 M1:SRC VSS:25 30000.0
R1_5 M1:SRC VSS:10 30000.0
R1_6 M1:SRC VSS:40 15000.0
R1_7 M2:DRN VSS:24 30000.0
R1_8 M2:DRN VSS:9 30000.0
R1_9 M2:DRN VSS:38 15000.0
R1_10 M3:SRC VSS:23 30000.0
R1_11 M3:SRC VSS:8 30000.0
R1_12 M3:SRC VSS:36 15000.0
R1_13 M4:DRN VSS:23 30000.0
R1_14 M4:DRN VSS:8 30000.0
R1_15 M4:DRN VSS:36 15000.0
R1_16 M5:SRC VSS:22 30000.0
R1_17 M5:SRC VSS:7 30000.0
R1_18 M5:SRC VSS:34 15000.0
R1_19 VSS:7 VSS:34 7.8411
R1_20 VSS:7 VSS:31 12.4587
R1_21 VSS:8 VSS:36 7.84041
R1_22 VSS:8 VSS:30 12.4587
R1_23 VSS:9 VSS:38 7.8411
R1_24 VSS:9 VSS:29 12.4587
R1_25 VSS:10 VSS:40 7.8411
R1_26 VSS:10 VSS:18 12.4587
R1_27 VSS:11 VSS:28 17.9166
R1_28 VSS:11 VSS:12 25.0832
R1_29 VSS:11 VSS:31 31.764
R1_30 VSS:12 VSS:13 63.5281
R1_31 VSS:12 VSS:14 25.0832
R1_32 VSS:13 VSS:31 50.1851
R1_33 VSS:13 VSS:30 50.1851
R1_34 VSS:14 VSS:30 31.764
R1_35 VSS:15 VSS:30 50.1851
R1_36 VSS:15 VSS:29 50.1851
R1_37 VSS:16 VSS:17 25.0832
R1_38 VSS:16 VSS:29 31.764
R1_39 VSS:17 VSS:18 31.764
R1_40 VSS:17 VSS:19 25.0832
R1_41 VSS:18 VSS:20 50.1851
R1_42 VSS:18 VSS:29 44.9024
R1_43 VSS:19 VSS:20 63.5281
R1_44 VSS:19 VSS:42 17.9166
R1_45 VSS:20 VSS:33 39.6198
R1_46 VSS:21 VSS:26 7778.54
R1_47 VSS:22 VSS:34 7.8411
R1_48 VSS:22 VSS:35 1.77981
R1_49 VSS:23 VSS:36 7.84041
R1_50 VSS:23 VSS:37 1.77981
R1_51 VSS:24 VSS:38 7.8411
R1_52 VSS:24 VSS:39 1.77981
R1_53 VSS:25 VSS:40 7.8411
R1_54 VSS:25 VSS:41 1.77981
R1_55 VSS:26 VSS:27 2423.78
R1_56 VSS:31 VSS:32 34.3372
R1_57 VSS:31 VSS:21 0.01

*|NET VDD 5.42802e-05PF
*|P (VDD B 0 0.1470 0.1440)
*|I (M10:SRC M10 SRC B 0 0.0360 0.1080)
*|I (M6:SRC M6 SRC B 0 0.2460 0.1080)
C2_1 VDD VSS:18 7.79004e-20
C2_2 VDD:15 VSS:18 1.66467e-19
C2_3 VDD:18 VSS:18 6.70874e-21
C2_4 VDD:21 VSS:18 4.01983e-21
C2_5 VDD:23 VSS:18 6.38861e-20
C2_6 VDD VSS:21 1.63594e-18
C2_7 VDD:4 VSS:21 8.02586e-19
C2_8 VDD:15 VSS:21 3.57239e-19
C2_9 VDD:23 VSS:21 1.49934e-18
C2_10 VDD VSS:28 1.16333e-18
C2_11 VDD:15 VSS:28 2.76282e-20
C2_12 VDD VSS:31 8.78916e-22
C2_13 VDD:18 VSS:31 3.86285e-21
C2_14 VDD:23 VSS:31 1.20446e-19
Cg2_15 VDD VSS 8.59786e-18
Cg2_16 VDD:4 VSS 2.52098e-19
Cg2_17 VDD:5 VSS 1.90317e-19
Cg2_18 VDD:15 VSS 1.49228e-17
Cg2_19 VDD:18 VSS 5.43919e-21
Cg2_20 VDD:21 VSS 5.43766e-21
Cg2_21 VDD:23 VSS 7.87308e-19
R2_1 VDD VDD:9 25.0832
R2_2 VDD VDD:11 63.5281
R2_3 VDD VDD:12 25.0832
R2_4 VDD VDD:20 0.1
R2_5 M10:SRC VDD:18 30000.0
R2_6 M10:SRC VDD:4 30000.0
R2_7 M10:SRC VDD:26 15000.0
R2_8 M6:SRC VDD:21 30000.0
R2_9 M6:SRC VDD:5 30000.0
R2_10 M6:SRC VDD:28 15000.0
R2_11 VDD:4 VDD:26 7.8411
R2_12 VDD:4 VDD:27 1.77981
R2_13 VDD:5 VDD:28 7.8411
R2_14 VDD:5 VDD:29 1.77981
R2_15 VDD:6 VDD:30 17.9166
R2_16 VDD:6 VDD:7 25.0832
R2_17 VDD:6 VDD:23 31.764
R2_18 VDD:7 VDD:8 63.5281
R2_19 VDD:7 VDD:9 25.0832
R2_20 VDD:8 VDD:23 50.1851
R2_21 VDD:8 VDD:10 55.4677
R2_22 VDD:9 VDD:10 63.5281
R2_23 VDD:10 VDD:11 55.4677
R2_24 VDD:11 VDD:13 55.4677
R2_25 VDD:12 VDD:13 63.5281
R2_26 VDD:12 VDD:14 25.0832
R2_27 VDD:13 VDD:15 50.1851
R2_28 VDD:14 VDD:15 31.764
R2_29 VDD:14 VDD:16 25.0832
R2_30 VDD:15 VDD:17 50.1851
R2_31 VDD:15 VDD:21 12.4587
R2_32 VDD:16 VDD:17 63.5281
R2_33 VDD:16 VDD:31 17.9166
R2_34 VDD:17 VDD:25 39.6198
R2_35 VDD:18 VDD:26 7.8411
R2_36 VDD:18 VDD:23 12.4587
R2_37 VDD:19 VDD:20 38622.8
R2_38 VDD:20 VDD:22 16037.5
R2_39 VDD:21 VDD:28 7.8411
R2_40 VDD:23 VDD:24 34.3372

*|NET Y 1.73716e-05PF
*|P (Y B 0 0.2730 0.0720)
*|I (M1:DRN M1 DRN B 0 0.2580 0.0360)
*|I (M6:DRN M6 DRN B 0 0.2580 0.1080)
C3_1 M1:DRN VSS:10 3.78986e-20
C3_2 Y:12 VSS:10 1.77132e-19
C3_3 M1:DRN VSS:18 5.55438e-20
C3_4 Y:4 VSS:18 2.32339e-18
C3_5 Y:12 VSS:18 1.89758e-19
C3_6 Y:12 VSS:21 6.0794e-19
C3_7 Y:12 VSS:26 7.77805e-20
C3_8 Y:12 VSS:27 2.01419e-19
C3_9 Y:4 VSS:28 7.02866e-20
C3_10 Y:12 VSS:28 1.55194e-18
C3_11 M1:DRN VSS:29 1.14927e-20
C3_12 Y:12 VSS:29 9.52251e-21
C3_13 Y:5 VDD 2.84607e-19
C3_14 Y:12 VDD 1.43894e-18
C3_15 M6:DRN VDD:5 3.78986e-20
C3_16 Y:12 VDD:5 1.77132e-19
C3_17 M6:DRN VDD:15 6.2592e-20
C3_18 Y:5 VDD:15 1.05946e-18
C3_19 Y:12 VDD:15 3.05127e-19
Cg3_20 Y:4 VSS 3.15906e-19
Cg3_21 Y:5 VSS 2.8933e-19
Cg3_22 Y:6 VSS 1.78742e-19
Cg3_23 Y:7 VSS 1.78742e-19
Cg3_24 Y:12 VSS 3.30692e-18
R3_1 Y Y:10 21.4999
R3_2 Y Y:8 21.4999
R3_3 M1:DRN Y:6 30000.0
R3_4 M1:DRN Y:4 30000.0
R3_5 M1:DRN Y:9 15000.0
R3_6 M6:DRN Y:7 30000.0
R3_7 M6:DRN Y:5 30000.0
R3_8 M6:DRN Y:11 15000.0
R3_9 Y:4 Y:9 9.78801
R3_10 Y:5 Y:11 9.78801
R3_11 Y:6 Y:9 9.78801
R3_12 Y:7 Y:11 9.78801
R3_13 Y:8 Y:9 63.5281
R3_14 Y:8 Y:12 7.8833
R3_15 Y:10 Y:11 63.5281
R3_16 Y:10 Y:13 7.94303

*|NET A 1.83893e-05PF
*|P (A B 0 0.0210 0.0720)
*|I (M10:GATE M10 GATE I 3.6e-19 0.0420 0.1080)
*|I (M5:GATE M5 GATE I 3.6e-19 0.0420 0.0360)
C4_1 A:10 VSS:7 2.44346e-19
C4_2 A:4 VSS:18 4.61602e-19
C4_3 A:5 VSS:18 7.89427e-21
C4_4 A:10 VSS:18 9.63817e-20
C4_5 A:10 VSS:21 9.56892e-19
C4_6 A:10 VSS:22 4.74872e-20
C4_7 A:4 VSS:28 2.75992e-20
C4_8 A:10 VSS:28 1.48034e-18
C4_9 A:8 VSS:31 9.16124e-19
C4_10 A:10 VSS:31 6.15563e-19
C4_11 A:4 VDD 4.02543e-21
C4_12 A:7 VDD 4.85422e-20
C4_13 A:8 VDD 2.83023e-20
C4_14 A:10 VDD 1.48818e-18
C4_15 A:10 VDD:4 1.1494e-19
C4_16 A:7 VDD:15 1.15802e-19
C4_17 A:8 VDD:18 1.48933e-20
C4_18 A:10 VDD:18 1.18559e-19
C4_19 A:8 VDD:23 1.58128e-18
C4_20 A:10 VDD:23 4.73109e-19
Cg4_21 A:4 VSS 1.09486e-19
Cg4_22 A:6 VSS 3.4119e-19
Cg4_23 A:7 VSS 2.31874e-19
Cg4_24 A:8 VSS 1.99342e-19
Cg4_25 A:10 VSS 3.76651e-18
R4_1 A A:10 29.3832
R4_2 A A:13 29.4429
R4_3 A A:9 63.5281
R4_4 M10:GATE A:7 13.1313
R4_5 M10:GATE A:6 7.57576
R4_6 M5:GATE A:5 7.57576
R4_7 M5:GATE A:4 7.57576
R4_8 A:4 A:11 5.55556
R4_9 A:5 A:8 10.6061
R4_10 A:6 A:8 10.6061
R4_11 A:8 A:9 27.7339
R4_12 A:9 A:12 7.92396

*|NET B 1.60368e-05PF
*|P (B B 0 0.0630 0.0720)
*|I (M4:GATE M4 GATE I 3.6e-19 0.0840 0.0360)
*|I (M9:GATE M9 GATE I 3.6e-19 0.0840 0.1080)
C5_1 B:10 VSS:7 1.53602e-20
C5_2 B:4 VSS:18 4.59524e-19
C5_3 B:5 VSS:18 7.89427e-21
C5_4 B:8 VSS:21 9.19865e-21
C5_5 B:10 VSS:21 4.07909e-19
C5_6 B:10 VSS:28 1.20515e-19
C5_7 B:10 VSS:31 3.53609e-20
C5_8 B:7 VDD 2.52952e-20
C5_9 B:8 VDD 4.20689e-20
C5_10 B:10 VDD 1.58564e-18
C5_11 B:10 VDD:4 8.37832e-20
C5_12 B:7 VDD:15 1.15459e-19
C5_13 B:10 VDD:23 1.08178e-19
C5_14 B:10 A:10 3.24445e-18
Cg5_15 B:4 VSS 1.09775e-19
Cg5_16 B:6 VSS 3.4119e-19
Cg5_17 B:7 VSS 2.29215e-19
Cg5_18 B:8 VSS 2.14171e-19
Cg5_19 B:10 VSS 2.02713e-18
R5_1 B B:10 12.8402
R5_2 B B:13 29.4429
R5_3 B B:9 63.5281
R5_4 M4:GATE B:5 7.57576
R5_5 M4:GATE B:4 7.57576
R5_6 M9:GATE B:7 13.1313
R5_7 M9:GATE B:6 7.57576
R5_8 B:4 B:11 5.55556
R5_9 B:5 B:8 10.6061
R5_10 B:6 B:8 10.6061
R5_11 B:8 B:9 27.7339
R5_12 B:9 B:12 7.92396

*|NET C 1.61003e-05PF
*|P (C B 0 0.1050 0.0720)
*|I (M3:GATE M3 GATE I 3.6e-19 0.1260 0.0360)
*|I (M8:GATE M8 GATE I 3.6e-19 0.1260 0.1080)
C6_1 C:4 VSS:18 4.59524e-19
C6_2 C:5 VSS:18 7.3486e-21
C6_3 C:8 VSS:21 9.19865e-21
C6_4 C:10 VSS:21 4.07909e-19
C6_5 C:10 VSS:28 1.49985e-19
C6_6 C:8 VSS:30 9.81086e-19
C6_7 C:10 VSS:30 4.03869e-19
C6_8 C:7 VDD 2.52952e-20
C6_9 C:8 VDD 4.20689e-20
C6_10 C:10 VDD 1.66777e-18
C6_11 C:7 VDD:15 1.15459e-19
C6_12 C:10 B:10 3.15161e-18
Cg6_13 C:4 VSS 1.09775e-19
Cg6_14 C:6 VSS 3.4119e-19
Cg6_15 C:7 VSS 2.29215e-19
Cg6_16 C:8 VSS 2.14171e-19
Cg6_17 C:10 VSS 2.02722e-18
R6_1 C C:10 12.8402
R6_2 C C:13 29.4429
R6_3 C C:9 63.5281
R6_4 M3:GATE C:5 7.57576
R6_5 M3:GATE C:4 7.57576
R6_6 M8:GATE C:7 13.1313
R6_7 M8:GATE C:6 7.57576
R6_8 C:4 C:11 5.55556
R6_9 C:5 C:8 10.6061
R6_10 C:6 C:8 10.6061
R6_11 C:8 C:9 27.7339
R6_12 C:9 C:12 7.92396

*|NET D 1.83649e-05PF
*|P (D B 0 0.1470 0.0720)
*|I (M2:GATE M2 GATE I 3.6e-19 0.1680 0.0360)
*|I (M7:GATE M7 GATE I 3.6e-19 0.1680 0.1080)
C7_1 D:10 VSS:8 1.53602e-20
C7_2 D:4 VSS:18 4.59524e-19
C7_3 D:5 VSS:18 7.89427e-21
C7_4 D:8 VSS:21 9.19865e-21
C7_5 D:10 VSS:21 3.52889e-19
C7_6 D:4 VSS:28 3.96906e-20
C7_7 D:10 VSS:28 1.25589e-19
C7_8 D:4 VSS:29 1.02173e-19
C7_9 D:10 VSS:30 3.53609e-20
C7_10 D:7 VDD 1.32534e-19
C7_11 D:8 VDD 4.20689e-20
C7_12 D:10 VDD 1.59978e-18
C7_13 D:7 VDD:15 1.16249e-19
C7_14 D:10 C:10 3.15161e-18
Cg7_15 D:4 VSS 2.40183e-19
Cg7_16 D:6 VSS 3.4119e-19
Cg7_17 D:7 VSS 1.57023e-19
Cg7_18 D:8 VSS 2.14171e-19
Cg7_19 D:10 VSS 2.00652e-18
R7_1 D D:10 12.8402
R7_2 D D:13 29.4429
R7_3 D D:9 63.5281
R7_4 M2:GATE D:5 7.57576
R7_5 M2:GATE D:4 7.57576
R7_6 M7:GATE D:7 13.1313
R7_7 M7:GATE D:6 7.57576
R7_8 D:4 D:11 5.55556
R7_9 D:5 D:8 10.6061
R7_10 D:6 D:8 10.6061
R7_11 D:8 D:9 27.7339
R7_12 D:9 D:12 7.92396

*|NET 12 6.43414e-07PF
*|I (M10:DRN M10 DRN B 0 0.0480 0.1080)
*|I (M9:SRC M9 SRC B 0 0.0780 0.1080)
C9_1 M10:DRN VDD 1.26579e-19
C9_2 M10:DRN VDD:4 2.82443e-20
C9_3 M10:DRN VDD:23 2.13821e-20
C9_4 M10:DRN B:8 3.20941e-19
C9_5 M10:DRN B:10 1.06636e-19
R9_1 M10:DRN M9:SRC 15000.0

*|NET 13 5.42563e-07PF
*|I (M8:SRC M8 SRC B 0 0.1200 0.1080)
*|I (M9:DRN M9 DRN B 0 0.0900 0.1080)
C10_1 M9:DRN VSS:30 4.14942e-20
C10_2 M9:DRN VDD 7.34908e-20
C10_3 M9:DRN C:8 3.20941e-19
C10_4 M9:DRN C:10 1.06636e-19
R10_1 M8:SRC M9:DRN 15000.0

*|NET 14 5.75069e-07PF
*|I (M7:SRC M7 SRC B 0 0.1620 0.1080)
*|I (M8:DRN M8 DRN B 0 0.1320 0.1080)
C11_1 M8:DRN VDD 1.07861e-19
C11_2 M8:DRN D:8 3.20941e-19
C11_3 M8:DRN D:10 1.06636e-19
R11_1 M7:SRC M8:DRN 15000.0

*|NET 4 6.31202e-05PF
*|I (M1:GATE M1 GATE I 3.6e-19 0.2520 0.0360)
*|I (M2:SRC M2 SRC B 0 0.1620 0.0360)
*|I (M3:DRN M3 DRN B 0 0.1320 0.0360)
*|I (M4:SRC M4 SRC B 0 0.0780 0.0360)
*|I (M5:DRN M5 DRN B 0 0.0480 0.0360)
*|I (M6:GATE M6 GATE I 3.6e-19 0.2520 0.1080)
*|I (M7:DRN M7 DRN B 0 0.1740 0.1080)
C12_1 M5:DRN VSS:7 2.82443e-20
C12_2 4:28 VSS:7 6.05689e-20
C12_3 M3:DRN VSS:8 3.00786e-20
C12_4 4:28 VSS:8 1.83714e-19
C12_5 4:28 VSS:9 1.32169e-19
C12_6 4:29 VSS:9 1.55558e-19
C12_7 4:9 VSS:10 1.25618e-18
C12_8 M3:DRN VSS:18 2.08949e-20
C12_9 M5:DRN VSS:18 2.09115e-20
C12_10 4:8 VSS:18 7.19201e-19
C12_11 4:9 VSS:18 7.08416e-19
C12_12 4:10 VSS:18 1.86805e-19
C12_13 4:13 VSS:18 2.32373e-18
C12_14 4:14 VSS:18 2.31904e-18
C12_15 4:16 VSS:18 9.91502e-19
C12_16 4:28 VSS:18 4.84007e-19
C12_17 4:30 VSS:18 4.44636e-19
C12_18 4:13 VSS:21 1.06816e-18
C12_19 4:14 VSS:21 7.88711e-21
C12_20 4:17 VSS:21 8.02001e-19
C12_21 4:28 VSS:21 6.16302e-19
C12_22 4:29 VSS:21 1.33662e-19
C12_23 4:30 VSS:21 3.18759e-19
C12_24 4:31 VSS:21 3.3935e-19
C12_25 4:13 VSS:23 2.47523e-20
C12_26 4:17 VSS:23 3.00786e-20
C12_27 4:28 VSS:23 5.43868e-20
C12_28 4:14 VSS:24 3.04542e-20
C12_29 4:18 VSS:24 3.00786e-20
C12_30 4:28 VSS:24 3.51022e-20
C12_31 4:29 VSS:24 2.27223e-20
C12_32 4:14 VSS:26 1.80439e-19
C12_33 4:28 VSS:26 4.81173e-20
C12_34 4:8 VSS:28 1.10252e-19
C12_35 4:13 VSS:28 1.74124e-19
C12_36 4:14 VSS:28 1.42842e-19
C12_37 4:28 VSS:28 9.60743e-18
C12_38 4:29 VSS:28 9.47674e-20
C12_39 4:30 VSS:28 9.63859e-19
C12_40 M7:DRN VSS:29 1.82318e-20
C12_41 4:8 VSS:29 1.17313e-19
C12_42 4:15 VSS:29 3.98254e-19
C12_43 4:28 VSS:29 2.28386e-19
C12_44 4:29 VSS:29 3.30225e-19
C12_45 4:30 VSS:29 2.08853e-19
C12_46 M3:DRN VSS:30 2.47523e-20
C12_47 4:28 VSS:30 4.7949e-19
C12_48 M5:DRN VSS:31 2.13821e-20
C12_49 4:28 VSS:31 6.53731e-20
C12_50 4:12 VDD 1.07146e-19
C12_51 4:15 VDD 1.56732e-19
C12_52 4:16 VDD 4.09483e-20
C12_53 4:28 VDD 8.88147e-19
C12_54 4:30 VDD 9.96698e-19
C12_55 4:31 VDD 1.23478e-18
C12_56 4:11 VDD:5 1.25618e-18
C12_57 4:10 VDD:15 1.83539e-19
C12_58 4:11 VDD:15 6.88271e-19
C12_59 4:12 VDD:15 3.72488e-19
C12_60 4:15 VDD:15 1.06187e-18
C12_61 4:16 VDD:15 1.65907e-18
C12_62 4:30 VDD:15 7.61346e-20
C12_63 4:16 VDD:21 1.52324e-20
C12_64 4:9 Y:12 2.1718e-19
C12_65 4:10 Y:12 2.30271e-19
C12_66 4:11 Y:12 1.99089e-19
C12_67 4:16 Y:12 2.90465e-19
C12_68 4:28 Y:12 4.10193e-19
C12_69 4:29 Y:12 5.86212e-19
C12_70 4:30 Y:12 6.95271e-19
C12_71 4:31 Y:12 9.15681e-19
C12_72 4:28 A:10 9.49071e-19
C12_73 4:29 A:10 8.35009e-20
C12_74 4:28 B:4 3.6149e-20
C12_75 4:28 B:5 8.15029e-20
C12_76 4:28 B:6 1.02157e-19
C12_77 4:13 B:8 9.63688e-19
C12_78 4:13 B:10 3.95506e-19
C12_79 4:28 B:10 1.69649e-18
C12_80 4:28 C:4 2.82147e-20
C12_81 4:28 C:5 5.16541e-20
C12_82 4:28 C:6 5.11439e-20
C12_83 4:13 C:10 3.53609e-20
C12_84 4:17 C:10 1.53602e-20
C12_85 4:28 C:10 1.67223e-18
C12_86 4:29 C:10 8.09701e-20
C12_87 4:30 C:10 2.91594e-20
C12_88 4:31 C:10 2.14354e-19
C12_89 4:28 D:4 9.41789e-21
C12_90 4:14 D:5 6.85438e-19
C12_91 4:18 D:5 1.22488e-18
C12_92 4:28 D:5 6.15418e-20
C12_93 4:29 D:5 1.00427e-19
C12_94 4:14 D:6 1.83918e-19
C12_95 4:28 D:6 1.24019e-19
C12_96 4:29 D:6 5.84592e-20
C12_97 4:31 D:6 5.71911e-20
C12_98 4:14 D:8 9.63688e-19
C12_99 4:30 D:8 1.84403e-19
C12_100 4:14 D:10 3.95506e-19
C12_101 4:28 D:10 1.61963e-18
C12_102 4:29 D:10 7.9302e-19
C12_103 4:30 D:10 4.31311e-19
C12_104 4:31 D:10 1.89542e-18
C12_105 4:13 M10:DRN 3.96311e-20
C12_106 4:14 M8:DRN 3.96311e-20
Cg12_107 4:8 VSS 1.00945e-19
Cg12_108 4:10 VSS 9.8281e-19
Cg12_109 4:12 VSS 1.68609e-19
Cg12_110 4:13 VSS 3.5694e-19
Cg12_111 4:14 VSS 3.30806e-19
Cg12_112 4:15 VSS 2.37768e-19
Cg12_113 4:16 VSS 4.69737e-19
Cg12_114 4:17 VSS 2.55731e-19
Cg12_115 4:18 VSS 2.31922e-19
Cg12_116 4:19 VSS 1.78742e-19
Cg12_117 4:28 VSS 1.77879e-18
Cg12_118 4:29 VSS 6.08648e-19
Cg12_119 4:30 VSS 8.46978e-19
Cg12_120 4:31 VSS 9.1102e-19
R12_1 M1:GATE 4:9 7.57576
R12_2 M1:GATE 4:8 7.57576
R12_3 M2:SRC 4:18 30000.0
R12_4 M2:SRC 4:35 20270.3
R12_5 M2:SRC 4:14 57692.3
R12_6 M2:SRC 4:25 30000.0
R12_7 M3:DRN 4:18 30000.0
R12_8 M3:DRN 4:35 20270.3
R12_9 M3:DRN 4:14 57692.3
R12_10 M3:DRN 4:25 30000.0
R12_11 M4:SRC 4:17 30000.0
R12_12 M4:SRC 4:34 20270.3
R12_13 M4:SRC 4:13 57692.3
R12_14 M4:SRC 4:23 30000.0
R12_15 M5:DRN 4:17 30000.0
R12_16 M5:DRN 4:34 20270.3
R12_17 M5:DRN 4:13 57692.3
R12_18 M5:DRN 4:23 30000.0
R12_19 M6:GATE 4:11 7.57576
R12_20 M6:GATE 4:10 7.57576
R12_21 M7:DRN 4:19 30000.0
R12_22 M7:DRN 4:15 30000.0
R12_23 M7:DRN 4:27 15000.0
R12_24 4:8 4:32 5.55556
R12_25 4:9 4:16 10.6061
R12_26 4:10 4:16 10.6061
R12_27 4:11 4:12 5.55556
R12_28 4:13 4:23 5.51634
R12_29 4:14 4:25 5.51634
R12_30 4:15 4:27 9.78801
R12_31 4:16 4:21 27.7339
R12_32 4:17 4:23 14.0605
R12_33 4:17 4:34 49500.0
R12_34 4:18 4:25 14.0605
R12_35 4:18 4:35 49500.0
R12_36 4:19 4:27 9.78801
R12_37 4:20 4:21 63.5281
R12_38 4:20 4:29 25.0832
R12_39 4:20 4:30 3.58332
R12_40 4:21 4:33 7.92396
R12_41 4:22 4:23 63.5281
R12_42 4:22 4:36 3.58332
R12_43 4:22 4:24 50.1665
R12_44 4:23 4:34 3.7634
R12_45 4:24 4:25 63.5281
R12_46 4:24 4:28 25.0832
R12_47 4:25 4:35 3.7634
R12_48 4:26 4:27 63.5281
R12_49 4:26 4:29 21.4999
R12_50 4:26 4:31 5.9722
R12_51 4:28 4:29 25.7999

*|NET _generated_15 2.86348e-06PF
C13_1 _generated_15:1 VSS:21 6.61239e-19
C13_2 _generated_15:1 VSS:28 2.25577e-20
C13_3 _generated_15:1 VSS:31 3.44976e-19
C13_4 _generated_15:1 A:10 3.06042e-19
Cg13_5 _generated_15:1 VSS 9.49624e-19
R13_1 _generated_15:1 _generated_15:2 28.2828

*|NET _generated_16 3.08088e-06PF
C14_1 _generated_16:1 VSS:18 1.47021e-19
C14_2 _generated_16:1 VSS:21 5.65589e-19
C14_3 _generated_16:1 VDD 4.89892e-20
C14_4 _generated_16:1 VDD:15 1.18927e-19
C14_5 _generated_16:1 VDD:23 3.74453e-19
C14_6 _generated_16:1 A:10 3.15962e-19
C14_7 _generated_16:1 _generated_15:1 5.79044e-19
Cg14_8 _generated_16:1 VSS 9.3089e-19
R14_1 _generated_16:1 _generated_16:2 28.2828

*|NET _generated_17 3.32711e-06PF
C15_1 _generated_17:1 VSS:18 9.22857e-19
C15_2 _generated_17:1 VSS:21 1.76795e-19
C15_3 _generated_17:1 VSS:28 7.90689e-20
C15_4 _generated_17:1 M7:DRN 5.43766e-21
C15_5 _generated_17:1 4:8 3.12363e-20
C15_6 _generated_17:1 4:9 4.74065e-20
C15_7 _generated_17:1 4:10 9.05603e-20
C15_8 _generated_17:1 4:30 1.76955e-19
Cg15_9 _generated_17:1 VSS 1.21713e-18
R15_1 _generated_17:1 _generated_17:2 28.2828

*|NET _generated_18 3.12877e-06PF
C16_1 _generated_18:1 VSS:21 3.79868e-19
C16_2 _generated_18:1 VDD 9.50481e-20
C16_3 _generated_18:1 VDD:15 5.04007e-19
C16_4 _generated_18:1 4:10 1.82326e-19
C16_5 _generated_18:1 4:11 4.74065e-20
C16_6 _generated_18:1 4:12 3.77558e-20
C16_7 _generated_18:1 4:30 3.77838e-20
C16_8 _generated_18:1 _generated_17:1 5.79666e-19
Cg16_9 _generated_18:1 VSS 1.26491e-18
R16_1 _generated_18:1 _generated_18:2 28.2828

*|NET _generated_19 5.32318e-06PF
C17_1 _generated_19:1 VSS:18 4.62142e-19
C17_2 _generated_19:1 VSS:21 2.98844e-20
C17_3 _generated_19:1 VSS:28 9.68154e-20
C17_4 _generated_19:1 VSS:29 5.66835e-22
C17_5 _generated_19:1 Y:4 3.81915e-19
C17_6 _generated_19:1 Y:12 5.46863e-20
C17_7 _generated_19:1 4:8 4.75026e-20
C17_8 _generated_19:1 4:10 2.39886e-19
Cg17_9 _generated_19:1 VSS 3.40563e-18
R17_1 _generated_19:1 _generated_19:2 28.2828

*|NET _generated_20 4.95261e-06PF
C18_1 _generated_20:1 VDD 1.77679e-19
C18_2 _generated_20:1 VDD:15 1.1978e-19
C18_3 _generated_20:1 Y:5 3.81915e-19
C18_4 _generated_20:1 Y:12 5.9231e-20
C18_5 _generated_20:1 4:10 2.39886e-19
C18_6 _generated_20:1 4:12 4.75026e-20
C18_7 _generated_20:1 _generated_19:1 6.0415e-19
Cg18_8 _generated_20:1 VSS 3.32246e-18
R18_1 _generated_20:1 _generated_20:2 28.2828

*
* Instance Section
*
MM1 M1:DRN M1:GATE M1:SRC VSS NMOS_LVT l=0.012u w=0.03u NF=1
MM10 M10:DRN M10:GATE M10:SRC VDD PMOS_LVT l=0.012u w=0.03u NF=1
MM2 M2:DRN M2:GATE M2:SRC VSS NMOS_LVT l=0.012u w=0.03u NF=1
MM3 M3:DRN M3:GATE M3:SRC VSS NMOS_LVT l=0.012u w=0.03u NF=1
MM4 M4:DRN M4:GATE M4:SRC VSS NMOS_LVT l=0.012u w=0.03u NF=1
MM5 M5:DRN M5:GATE M5:SRC VSS NMOS_LVT l=0.012u w=0.03u NF=1
MM6 M6:DRN M6:GATE M6:SRC VDD PMOS_LVT l=0.012u w=0.03u NF=1
MM7 M7:DRN M7:GATE M7:SRC VDD PMOS_LVT l=0.012u w=0.03u NF=1
MM8 M8:DRN M8:GATE M8:SRC VDD PMOS_LVT l=0.012u w=0.03u NF=1
MM9 M9:DRN M9:GATE M9:SRC VDD PMOS_LVT l=0.012u w=0.03u NF=1

.ENDS
