*
*|DSPF 1.3
*|DESIGN NOR2x2
*|DATE "Tue Nov  3 20:56:53 2026"
*|VENDOR "Synopsys"
*|PROGRAM "StarRC"
*|VERSION "X-2025.06-SP1"
*|DIVIDER /
*|DELIMITER :
**FORMAT SPF
*

** COMMENTS

** OPERATING_TEMPERATURE 25
** GLOBAL_TEMPERATURE 25
**
** TCAD_GRD_FILE /cedar/cedar_coe/ece-limsk/yhuang861/GRO/.planning/experiments_migrated_20261022/usc144_github_release_20261103/sources/github_FSPR.nxtgrd
**   TCAD_TIME_STAMP Tue Mar 31 05:07:55 2026
**   TCADGRD_VERSION 89

.SUBCKT NOR2x2 VSS VDD Y A B

*|GROUND_NET VSS

*|NET VSS 8.88578e-05PF
*|P (VSS B 0 0.1050 0.0000)
*|I (M1:DRN M1 DRN B 0 0.1740 0.0360)
*|I (M2:SRC M2 SRC B 0 0.1200 0.0360)
*|I (M3:DRN M3 DRN B 0 0.0900 0.0360)
*|I (M4:SRC M4 SRC B 0 0.0360 0.0360)
Cg1_1 VSS:6 VSS 2.52098e-19
Cg1_2 VSS:7 VSS 2.30244e-19
Cg1_3 VSS:8 VSS 1.78742e-19
Cg1_4 VSS:15 VSS 2.49035e-18
Cg1_5 VSS:16 VSS 3.30882e-17
Cg1_6 VSS:20 VSS 4.67272e-18
Cg1_7 VSS:22 VSS 6.33131e-18
Cg1_8 VSS:23 VSS 4.0433e-19
Cg1_9 VSS:24 VSS 4.72877e-19
R1_1 VSS VSS:10 25.0832
R1_2 VSS VSS:12 25.0832
R1_3 VSS VSS:23 31.764
R1_4 M1:DRN VSS:19 30000.0
R1_5 M1:DRN VSS:8 30000.0
R1_6 M1:DRN VSS:31 15000.0
R1_7 M2:SRC VSS:18 30000.0
R1_8 M2:SRC VSS:7 30000.0
R1_9 M2:SRC VSS:29 15000.0
R1_10 M3:DRN VSS:18 30000.0
R1_11 M3:DRN VSS:7 30000.0
R1_12 M3:DRN VSS:29 15000.0
R1_13 M4:SRC VSS:17 30000.0
R1_14 M4:SRC VSS:6 30000.0
R1_15 M4:SRC VSS:27 15000.0
R1_16 VSS:6 VSS:27 7.8411
R1_17 VSS:6 VSS:24 12.4587
R1_18 VSS:7 VSS:29 7.84041
R1_19 VSS:7 VSS:23 12.4587
R1_20 VSS:8 VSS:31 7.8411
R1_21 VSS:8 VSS:15 12.4587
R1_22 VSS:9 VSS:22 17.9166
R1_23 VSS:9 VSS:10 25.0832
R1_24 VSS:9 VSS:24 31.764
R1_25 VSS:10 VSS:11 63.5281
R1_26 VSS:11 VSS:24 50.1851
R1_27 VSS:11 VSS:23 50.1851
R1_28 VSS:12 VSS:13 63.5281
R1_29 VSS:12 VSS:14 25.0832
R1_30 VSS:13 VSS:23 50.1851
R1_31 VSS:13 VSS:15 50.1851
R1_32 VSS:14 VSS:15 31.764
R1_33 VSS:14 VSS:33 17.9166
R1_34 VSS:15 VSS:26 34.3372
R1_35 VSS:16 VSS:20 7778.54
R1_36 VSS:17 VSS:27 7.8411
R1_37 VSS:17 VSS:28 1.77981
R1_38 VSS:18 VSS:29 7.84041
R1_39 VSS:18 VSS:30 1.77981
R1_40 VSS:19 VSS:31 7.8411
R1_41 VSS:19 VSS:32 1.77981
R1_42 VSS:20 VSS:21 4070.12
R1_43 VSS:24 VSS:25 34.3372
R1_44 VSS:24 VSS:16 0.01

*|NET VDD 4.27571e-05PF
*|P (VDD B 0 0.1050 0.1440)
*|I (M7:SRC M7 SRC B 0 0.0780 0.1080)
*|I (M8:DRN M8 DRN B 0 0.0480 0.1080)
C2_1 VDD VSS:15 7.80663e-20
C2_2 VDD:8 VSS:15 3.83957e-20
C2_3 VDD VSS:16 1.26202e-18
C2_4 VDD:4 VSS:16 8.00833e-19
C2_5 VDD:8 VSS:16 1.49354e-18
C2_6 VDD VSS:22 5.93806e-19
C2_7 VDD:8 VSS:22 2.76282e-20
Cg2_8 VDD VSS 6.88027e-18
Cg2_9 VDD:4 VSS 2.61822e-19
Cg2_10 VDD:8 VSS 1.15299e-17
R2_1 VDD VDD:7 25.0832
R2_2 VDD VDD:9 63.5281
R2_3 VDD VDD:10 25.0832
R2_4 VDD VDD:14 38473.3
R2_5 M7:SRC VDD:15 30000.0
R2_6 M7:SRC VDD:4 30000.0
R2_7 M7:SRC VDD:18 15000.0
R2_8 M8:DRN VDD:15 30000.0
R2_9 M8:DRN VDD:4 30000.0
R2_10 M8:DRN VDD:18 15000.0
R2_11 VDD:4 VDD:18 7.84041
R2_12 VDD:4 VDD:19 1.77981
R2_13 VDD:5 VDD:6 63.5281
R2_14 VDD:5 VDD:20 17.9166
R2_15 VDD:5 VDD:7 25.0832
R2_16 VDD:6 VDD:16 39.6198
R2_17 VDD:6 VDD:8 50.1851
R2_18 VDD:7 VDD:8 31.764
R2_19 VDD:8 VDD:9 50.1851
R2_20 VDD:8 VDD:15 12.4587
R2_21 VDD:9 VDD:11 55.4677
R2_22 VDD:10 VDD:11 63.5281
R2_23 VDD:10 VDD:12 25.0832
R2_24 VDD:11 VDD:13 55.4677
R2_25 VDD:12 VDD:13 63.5281
R2_26 VDD:12 VDD:21 17.9166
R2_27 VDD:13 VDD:17 39.6198
R2_28 VDD:15 VDD:18 7.84041

*|NET Y 3.95848e-05PF
*|P (Y B 0 0.1050 0.0288)
*|I (M1:SRC M1 SRC B 0 0.1620 0.0360)
*|I (M2:DRN M2 DRN B 0 0.1320 0.0360)
*|I (M3:SRC M3 SRC B 0 0.0780 0.0360)
*|I (M4:DRN M4 DRN B 0 0.0480 0.0360)
*|I (M5:SRC M5 SRC B 0 0.1620 0.1080)
*|I (M6:DRN M6 DRN B 0 0.1320 0.1080)
C3_1 M4:DRN VSS:6 2.82443e-20
C3_2 Y:17 VSS:6 4.44601e-20
C3_3 Y:18 VSS:6 4.52429e-20
C3_4 M2:DRN VSS:7 3.18486e-20
C3_5 Y:17 VSS:7 1.74347e-19
C3_6 Y:19 VSS:7 6.61292e-20
C3_7 M2:DRN VSS:15 2.3942e-20
C3_8 M4:DRN VSS:15 2.09115e-20
C3_9 Y:8 VSS:15 2.32373e-18
C3_10 Y:9 VSS:15 2.3312e-18
C3_11 Y:17 VSS:15 3.40287e-19
C3_12 Y:8 VSS:16 1.06665e-18
C3_13 Y:10 VSS:16 8.01814e-19
C3_14 Y:17 VSS:16 3.24089e-19
C3_15 Y:18 VSS:16 3.80671e-19
C3_16 Y:19 VSS:16 4.46602e-20
C3_17 Y:8 VSS:18 2.13821e-20
C3_18 Y:10 VSS:18 2.82443e-20
C3_19 Y:17 VSS:18 5.3074e-20
C3_20 Y:9 VSS:19 3.42114e-20
C3_21 Y:11 VSS:19 2.82443e-20
C3_22 Y:17 VSS:20 5.18785e-20
C3_23 Y:8 VSS:22 1.81352e-19
C3_24 Y:9 VSS:22 1.8386e-19
C3_25 Y:17 VSS:22 6.8802e-18
C3_26 Y:18 VSS:22 5.05808e-20
C3_27 Y:19 VSS:22 5.05808e-20
C3_28 M2:DRN VSS:23 3.91522e-20
C3_29 Y:17 VSS:23 6.06241e-19
C3_30 Y:19 VSS:23 1.41851e-19
C3_31 M4:DRN VSS:24 2.13821e-20
C3_32 Y:17 VSS:24 5.05156e-20
C3_33 Y:18 VSS:24 6.33877e-20
C3_34 Y:9 VDD 2.75339e-19
C3_35 Y:17 VDD 3.00865e-20
C3_36 Y:8 VDD:8 4.24664e-19
C3_37 Y:9 VDD:8 1.23574e-18
C3_38 Y:8 VDD:15 2.18667e-20
Cg3_39 Y:8 VSS 3.91701e-19
Cg3_40 Y:9 VSS 7.53798e-19
Cg3_41 Y:10 VSS 2.70018e-19
Cg3_42 Y:11 VSS 2.52098e-19
Cg3_43 Y:12 VSS 2.61822e-19
Cg3_44 Y:17 VSS 1.3847e-18
Cg3_45 Y:18 VSS 5.75201e-19
Cg3_46 Y:19 VSS 4.16453e-19
R3_1 Y Y:17 25.0832
R3_2 Y Y:18 25.0832
R3_3 M1:SRC Y:20 30000.0
R3_4 M1:SRC Y:11 30000.0
R3_5 M1:SRC Y:16 15000.0
R3_6 M2:DRN Y:20 30000.0
R3_7 M2:DRN Y:11 30000.0
R3_8 M2:DRN Y:16 15000.0
R3_9 M3:SRC Y:10 30000.0
R3_10 M3:SRC Y:8 30000.0
R3_11 M3:SRC Y:14 15000.0
R3_12 M4:DRN Y:10 30000.0
R3_13 M4:DRN Y:8 30000.0
R3_14 M4:DRN Y:14 15000.0
R3_15 M5:SRC Y:12 30000.0
R3_16 M5:SRC Y:9 30000.0
R3_17 M5:SRC Y:21 15000.0
R3_18 M6:DRN Y:12 30000.0
R3_19 M6:DRN Y:9 30000.0
R3_20 M6:DRN Y:21 15000.0
R3_21 Y:8 Y:14 9.78705
R3_22 Y:9 Y:12 18.6881
R3_23 Y:9 Y:20 24.9174
R3_24 Y:9 Y:21 7.84041
R3_25 Y:10 Y:14 9.78705
R3_26 Y:11 Y:16 9.78705
R3_27 Y:12 Y:21 49500.0
R3_28 Y:13 Y:14 63.5281
R3_29 Y:13 Y:18 4.29998
R3_30 Y:13 Y:22 15.1097
R3_31 Y:15 Y:16 63.5281
R3_32 Y:15 Y:17 4.29998
R3_33 Y:15 Y:19 15.1097
R3_34 Y:16 Y:20 8.89731

*|NET A 2.51794e-05PF
*|P (A B 0 0.0630 0.0865)
*|I (M3:GATE M3 GATE I 3.6e-19 0.0840 0.0360)
*|I (M4:GATE M4 GATE I 3.6e-19 0.0420 0.0360)
*|I (M7:GATE M7 GATE I 3.6e-19 0.0840 0.1080)
*|I (M8:GATE M8 GATE I 3.6e-19 0.0420 0.1080)
C4_1 A:20 VSS:6 2.31333e-19
C4_2 A:6 VSS:15 4.61217e-19
C4_3 A:7 VSS:15 7.89427e-21
C4_4 A:11 VSS:15 4.59524e-19
C4_5 A:12 VSS:15 7.89427e-21
C4_6 A:19 VSS:15 9.64637e-21
C4_7 A:20 VSS:15 9.59477e-20
C4_8 A:17 VSS:16 8.02484e-20
C4_9 A:19 VSS:16 3.45533e-20
C4_10 A:20 VSS:16 9.06364e-19
C4_11 A:20 VSS:17 4.74872e-20
C4_12 A:6 VSS:22 6.94049e-21
C4_13 A:17 VSS:22 1.03862e-19
C4_14 A:19 VSS:22 2.2061e-19
C4_15 A:20 VSS:22 1.68375e-18
C4_16 A:19 VSS:24 1.51549e-20
C4_17 A:20 VSS:24 6.94767e-19
C4_18 A:10 VDD 4.17741e-20
C4_19 A:15 VDD 4.17741e-20
C4_20 A:17 VDD 1.4932e-19
C4_21 A:19 VDD 1.38654e-19
C4_22 A:20 VDD 2.4177e-19
C4_23 A:17 VDD:4 1.30111e-20
C4_24 A:20 VDD:4 1.4749e-20
C4_25 A:10 VDD:8 1.15217e-19
C4_26 A:15 VDD:8 1.15217e-19
C4_27 A:17 VDD:8 1.89246e-20
C4_28 A:20 VDD:8 2.02876e-19
C4_29 A:17 VDD:15 1.12789e-20
C4_30 A:19 VDD:15 1.12789e-20
C4_31 A:20 VDD:15 1.16884e-21
C4_32 A:20 Y:8 1.23566e-19
C4_33 A:11 Y:17 2.82147e-20
C4_34 A:12 Y:17 6.48578e-20
C4_35 A:17 Y:17 6.06295e-19
C4_36 A:20 Y:17 9.67846e-19
C4_37 A:20 Y:18 2.66368e-18
C4_38 A:20 Y:19 3.11779e-20
Cg4_39 A:6 VSS 1.08885e-19
Cg4_40 A:8 VSS 3.4119e-19
Cg4_41 A:10 VSS 2.27134e-19
Cg4_42 A:11 VSS 1.09775e-19
Cg4_43 A:13 VSS 3.4119e-19
Cg4_44 A:15 VSS 2.27134e-19
Cg4_45 A:16 VSS 4.71178e-20
Cg4_46 A:17 VSS 5.3459e-19
Cg4_47 A:18 VSS 4.71178e-20
Cg4_48 A:19 VSS 4.6962e-19
Cg4_49 A:20 VSS 2.89845e-18
R4_1 A A:19 8.61542
R4_2 A A:17 8.61542
R4_3 M3:GATE A:12 7.57576
R4_4 M3:GATE A:11 7.57576
R4_5 M4:GATE A:7 7.57576
R4_6 M4:GATE A:6 7.57576
R4_7 M7:GATE A:14 7.57576
R4_8 M7:GATE A:13 7.57576
R4_9 M8:GATE A:9 7.57576
R4_10 M8:GATE A:8 7.57576
R4_11 A:6 A:21 5.55556
R4_12 A:7 A:16 17.9293
R4_13 A:8 A:16 3.28283
R4_14 A:9 A:10 5.55556
R4_15 A:11 A:22 5.55556
R4_16 A:12 A:18 17.9293
R4_17 A:13 A:18 3.28283
R4_18 A:14 A:15 5.55556
R4_19 A:16 A:19 63.5281
R4_20 A:17 A:18 63.5281
R4_21 A:19 A:20 7.2529
R4_22 A:20 A:23 32.011

*|NET B 3.40477e-05PF
*|P (B B 0 0.1470 0.0865)
*|I (M1:GATE M1 GATE I 3.6e-19 0.1680 0.0360)
*|I (M2:GATE M2 GATE I 3.6e-19 0.1260 0.0360)
*|I (M5:GATE M5 GATE I 3.6e-19 0.1680 0.1080)
*|I (M6:GATE M6 GATE I 3.6e-19 0.1260 0.1080)
C5_1 B:7 VSS:7 1.22701e-18
C5_2 B:20 VSS:8 1.15286e-19
C5_3 B:6 VSS:15 4.60197e-19
C5_4 B:7 VSS:15 7.89427e-21
C5_5 B:11 VSS:15 4.6982e-19
C5_6 B:12 VSS:15 7.89427e-21
C5_7 B:18 VSS:15 3.41179e-20
C5_8 B:20 VSS:15 1.13681e-18
C5_9 B:16 VSS:16 9.03225e-20
C5_10 B:18 VSS:16 1.42358e-19
C5_11 B:20 VSS:16 5.8645e-19
C5_12 B:6 VSS:19 1.7219e-20
C5_13 B:20 VSS:19 3.95537e-20
C5_14 B:20 VSS:20 3.66301e-20
C5_15 B:20 VSS:21 2.56172e-19
C5_16 B:6 VSS:22 2.84649e-20
C5_17 B:11 VSS:22 9.50315e-20
C5_18 B:16 VSS:22 9.49002e-20
C5_19 B:18 VSS:22 4.38464e-19
C5_20 B:20 VSS:22 1.46012e-18
C5_21 B:7 VSS:23 6.85177e-19
C5_22 B:8 VSS:23 1.83539e-19
C5_23 B:11 VSS:23 3.93596e-22
C5_24 B:16 M6:DRN 1.12789e-20
C5_25 B:18 M6:DRN 1.12789e-20
C5_26 B:20 M6:DRN 2.64394e-20
C5_27 B:11 Y:9 1.83918e-19
C5_28 B:12 Y:9 6.89692e-19
C5_29 B:13 Y:9 9.78265e-19
C5_30 B:14 Y:9 6.86286e-19
C5_31 B:15 Y:9 1.82222e-19
C5_32 B:18 Y:9 3.0924e-20
C5_33 B:20 Y:9 1.0997e-18
C5_34 B:12 Y:11 1.24235e-18
C5_35 B:20 Y:11 8.37831e-20
C5_36 B:14 Y:12 1.21905e-18
C5_37 B:18 Y:12 1.30111e-20
C5_38 B:20 Y:12 1.4749e-20
C5_39 B:6 Y:17 6.13456e-21
C5_40 B:7 Y:17 6.4725e-20
C5_41 B:8 Y:17 8.32115e-20
C5_42 B:12 Y:17 5.98514e-20
C5_43 B:16 Y:17 6.09463e-19
C5_44 B:20 Y:17 8.55988e-19
C5_45 B:20 Y:18 4.00366e-20
C5_46 B:7 Y:19 9.68543e-20
C5_47 B:8 Y:19 9.78387e-20
C5_48 B:12 Y:19 7.19932e-20
C5_49 B:13 Y:19 6.56257e-20
C5_50 B:20 Y:19 2.41906e-18
C5_51 B:16 A:17 5.9136e-19
C5_52 B:18 A:17 6.6716e-20
C5_53 B:20 A:17 1.08555e-20
C5_54 B:16 A:19 4.46418e-20
C5_55 B:20 A:19 1.51478e-20
C5_56 B:16 A:20 3.29302e-20
C5_57 B:18 A:20 2.89491e-20
C5_58 B:20 A:20 9.40838e-19
Cg5_59 B:6 VSS 2.16223e-19
Cg5_60 B:8 VSS 3.4119e-19
Cg5_61 B:10 VSS 3.84125e-19
Cg5_62 B:11 VSS 9.99012e-20
Cg5_63 B:13 VSS 9.45115e-19
Cg5_64 B:15 VSS 4.53927e-19
Cg5_65 B:16 VSS 6.51203e-19
Cg5_66 B:17 VSS 4.71178e-20
Cg5_67 B:18 VSS 6.97879e-19
Cg5_68 B:19 VSS 6.20633e-20
Cg5_69 B:20 VSS 2.45039e-18
R5_1 B B:18 8.61542
R5_2 B B:16 8.61542
R5_3 M1:GATE B:12 7.57576
R5_4 M1:GATE B:11 7.57576
R5_5 M2:GATE B:7 7.57576
R5_6 M2:GATE B:6 7.57576
R5_7 M5:GATE B:14 7.57576
R5_8 M5:GATE B:13 7.57576
R5_9 M6:GATE B:9 7.57576
R5_10 M6:GATE B:8 7.57576
R5_11 B:6 B:21 5.55556
R5_12 B:7 B:17 17.9293
R5_13 B:8 B:17 3.28283
R5_14 B:9 B:10 5.55556
R5_15 B:11 B:22 5.55556
R5_16 B:12 B:19 17.9293
R5_17 B:13 B:19 3.28283
R5_18 B:14 B:15 5.55556
R5_19 B:16 B:17 63.5281
R5_20 B:18 B:19 63.5281
R5_21 B:18 B:20 7.28495
R5_22 B:20 B:23 35.5346

*|NET 10 4.55555e-07PF
*|I (M6:SRC M6 SRC B 0 0.1200 0.1080)
*|I (M7:DRN M7 DRN B 0 0.0900 0.1080)
C7_1 M7:DRN VSS:23 1.9063e-19
C7_2 M7:DRN VDD 7.21958e-20
C7_3 M7:DRN VDD:4 2.91454e-20
C7_4 M7:DRN VDD:8 2.30376e-20
Cg7_5 M7:DRN VSS 2.33617e-20
R7_1 M6:SRC M7:DRN 15000.0

*|NET 4 3.99545e-05PF
*|I (M5:DRN M5 DRN B 0 0.1740 0.1080)
*|I (M8:SRC M8 SRC B 0 0.0360 0.1080)
C8_1 M5:DRN VSS:15 1.82777e-20
C8_2 M8:SRC VSS:15 6.4072e-21
C8_3 4:3 VSS:15 6.27723e-20
C8_4 4:4 VSS:15 3.99748e-19
C8_5 4:3 VSS:16 1.06207e-18
C8_6 4:5 VSS:16 8.00916e-19
C8_7 4:11 VSS:16 1.20157e-18
C8_8 4:11 VSS:22 4.13756e-20
C8_9 4:11 VSS:23 1.00004e-19
C8_10 M8:SRC VSS:24 2.05624e-20
C8_11 4:3 VSS:24 4.49717e-19
C8_12 4:3 VDD 2.99033e-19
C8_13 4:4 VDD 2.26692e-19
C8_14 4:11 VDD 1.23863e-17
C8_15 4:11 VDD:4 2.24377e-19
C8_16 4:3 VDD:8 1.4613e-18
C8_17 4:4 VDD:8 1.06277e-18
C8_18 4:11 VDD:8 3.12889e-19
C8_19 4:3 VDD:15 2.30376e-20
C8_20 4:5 VDD:15 2.91454e-20
C8_21 4:11 VDD:15 5.59623e-20
C8_22 4:11 M6:DRN 4.58838e-20
C8_23 M5:DRN Y:9 3.58669e-20
C8_24 4:11 Y:9 3.4885e-19
C8_25 M5:DRN Y:12 2.91454e-20
C8_26 4:11 Y:12 2.99665e-19
C8_27 4:11 Y:17 3.74896e-19
C8_28 4:11 Y:18 1.08401e-19
C8_29 4:11 Y:19 8.4853e-20
C8_30 4:11 A:9 5.30317e-20
C8_31 4:11 A:10 1.9335e-20
C8_32 4:11 A:14 5.30317e-20
C8_33 4:11 A:15 1.9335e-20
C8_34 4:11 A:17 1.70982e-18
C8_35 M8:SRC A:19 3.63292e-20
C8_36 4:3 A:19 3.72618e-20
C8_37 4:5 A:19 2.2542e-20
C8_38 4:11 A:19 1.71151e-18
C8_39 M8:SRC A:20 1.22729e-21
C8_40 4:3 A:20 1.78594e-19
C8_41 4:5 A:20 1.40721e-20
C8_42 4:11 A:20 3.0688e-18
C8_43 4:11 B:9 5.30317e-20
C8_44 4:11 B:10 1.9335e-20
C8_45 4:11 B:13 6.62808e-20
C8_46 4:11 B:14 4.15758e-20
C8_47 4:11 B:15 3.14075e-20
C8_48 4:11 B:16 1.72744e-18
C8_49 M5:DRN B:18 3.63292e-20
C8_50 4:11 B:18 1.7588e-18
C8_51 M5:DRN B:20 1.56788e-21
C8_52 4:4 B:20 1.26854e-19
C8_53 4:6 B:20 2.70766e-21
C8_54 4:11 B:20 2.88487e-18
C8_55 4:11 M7:DRN 1.17185e-19
Cg8_56 M8:SRC VSS 5.43919e-21
Cg8_57 4:3 VSS 3.45073e-19
Cg8_58 4:4 VSS 2.8933e-19
Cg8_59 4:5 VSS 2.39223e-19
Cg8_60 4:6 VSS 1.78742e-19
Cg8_61 4:11 VSS 2.64955e-18
R8_1 M5:DRN 4:4 30000.0
R8_2 M5:DRN 4:13 20089.3
R8_3 M5:DRN 4:6 59210.5
R8_4 M5:DRN 4:10 30000.0
R8_5 M8:SRC 4:3 30000.0
R8_6 M8:SRC 4:12 20089.3
R8_7 M8:SRC 4:5 59210.5
R8_8 M8:SRC 4:8 30000.0
R8_9 4:3 4:8 14.1199
R8_10 4:3 4:12 8.62521
R8_11 4:4 4:10 14.1199
R8_12 4:4 4:13 8.62521
R8_13 4:5 4:8 5.45756
R8_14 4:6 4:10 5.45756
R8_15 4:7 4:8 63.5281
R8_16 4:7 4:11 3.58332
R8_17 4:7 4:9 100.333
R8_18 4:8 4:12 43800.0
R8_19 4:9 4:10 63.5281
R8_20 4:9 4:14 3.58332
R8_21 4:10 4:13 43800.0

*|NET _generated_11 2.86348e-06PF
C9_1 _generated_11:1 VSS:16 6.61239e-19
C9_2 _generated_11:1 VSS:22 2.25577e-20
C9_3 _generated_11:1 VSS:24 3.44976e-19
C9_4 _generated_11:1 A:20 3.06042e-19
Cg9_5 _generated_11:1 VSS 9.49624e-19
R9_1 _generated_11:1 _generated_11:2 28.2828

*|NET _generated_12 3.13649e-06PF
C10_1 _generated_12:1 VSS:15 1.47021e-19
C10_2 _generated_12:1 VSS:16 6.49559e-19
C10_3 _generated_12:1 VDD 5.00228e-20
C10_4 _generated_12:1 VDD:8 1.18927e-19
C10_5 _generated_12:1 A:19 1.54153e-20
C10_6 _generated_12:1 A:20 1.79555e-19
C10_7 _generated_12:1 4:3 3.44035e-19
C10_8 _generated_12:1 4:11 1.56391e-19
C10_9 _generated_12:1 _generated_11:1 5.79044e-19
Cg10_10 _generated_12:1 VSS 8.96519e-19
R10_1 _generated_12:1 _generated_12:2 28.2828

*|NET _generated_13 5.35325e-06PF
C11_1 _generated_13:1 VSS:15 9.21148e-19
C11_2 _generated_13:1 VSS:16 2.98844e-20
C11_3 _generated_13:1 VSS:22 9.68154e-20
C11_4 _generated_13:1 B:11 1.58022e-21
C11_5 _generated_13:1 B:13 2.39886e-19
C11_6 _generated_13:1 B:20 5.2183e-20
Cg11_7 _generated_13:1 VSS 3.4076e-18
R11_1 _generated_13:1 _generated_13:2 28.2828

*|NET _generated_14 4.98742e-06PF
C12_1 _generated_14:1 VDD 1.91825e-19
C12_2 _generated_14:1 VDD:8 1.19386e-19
C12_3 _generated_14:1 B:13 2.3829e-19
C12_4 _generated_14:1 B:15 4.75026e-20
C12_5 _generated_14:1 B:19 4.85181e-20
C12_6 _generated_14:1 B:20 3.14043e-20
C12_7 _generated_14:1 4:4 3.81915e-19
C12_8 _generated_14:1 _generated_13:1 6.0415e-19
Cg12_9 _generated_14:1 VSS 3.32443e-18
R12_1 _generated_14:1 _generated_14:2 28.2828

*
* Instance Section
*
MM1 M1:DRN M1:GATE M1:SRC VSS NMOS_LVT l=0.012u w=0.03u NF=1
MM2 M2:DRN M2:GATE M2:SRC VSS NMOS_LVT l=0.012u w=0.03u NF=1
MM3 M3:DRN M3:GATE M3:SRC VSS NMOS_LVT l=0.012u w=0.03u NF=1
MM4 M4:DRN M4:GATE M4:SRC VSS NMOS_LVT l=0.012u w=0.03u NF=1
MM5 M5:DRN M5:GATE M5:SRC VDD PMOS_LVT l=0.012u w=0.03u NF=1
MM6 M6:DRN M6:GATE M6:SRC VDD PMOS_LVT l=0.012u w=0.03u NF=1
MM7 M7:DRN M7:GATE M7:SRC VDD PMOS_LVT l=0.012u w=0.03u NF=1
MM8 M8:DRN M8:GATE M8:SRC VDD PMOS_LVT l=0.012u w=0.03u NF=1

.ENDS
