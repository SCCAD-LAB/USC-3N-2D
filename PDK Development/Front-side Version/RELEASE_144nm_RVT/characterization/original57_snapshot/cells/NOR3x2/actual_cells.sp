*
*|DSPF 1.3
*|DESIGN NOR3x2
*|DATE "Tue Nov  3 21:33:27 2026"
*|VENDOR "Synopsys"
*|PROGRAM "StarRC"
*|VERSION "X-2025.06-SP1"
*|DIVIDER /
*|DELIMITER :
**FORMAT SPF
*

** COMMENTS

** OPERATING_TEMPERATURE 25
** GLOBAL_TEMPERATURE 25
**
** TCAD_GRD_FILE /cedar/cedar_coe/ece-limsk/yhuang861/GRO/.planning/experiments_migrated_20261022/usc144_github_release_20261103/sources/github_FSPR.nxtgrd
**   TCAD_TIME_STAMP Tue Mar 31 05:07:55 2026
**   TCADGRD_VERSION 89

.SUBCKT NOR3x2 VSS VDD Y A C B

*|GROUND_NET VSS

*|NET VSS 0.000121444PF
*|P (VSS B 0 0.1470 0.0000)
*|I (M1:SRC M1 SRC B 0 0.2460 0.0360)
*|I (M2:DRN M2 DRN B 0 0.2160 0.0360)
*|I (M3:SRC M3 SRC B 0 0.1620 0.0360)
*|I (M4:DRN M4 DRN B 0 0.1320 0.0360)
*|I (M5:SRC M5 SRC B 0 0.0780 0.0360)
*|I (M6:DRN M6 DRN B 0 0.0480 0.0360)
Cg1_1 VSS:8 VSS 2.52665e-19
Cg1_2 VSS:9 VSS 2.55711e-19
Cg1_3 VSS:10 VSS 2.56341e-19
Cg1_4 VSS:19 VSS 2.95021e-18
Cg1_5 VSS:22 VSS 4.31292e-17
Cg1_6 VSS:26 VSS 4.9419e-18
Cg1_7 VSS:28 VSS 8.31629e-18
Cg1_8 VSS:29 VSS 5.23759e-19
Cg1_9 VSS:30 VSS 4.80971e-19
R1_1 VSS VSS:14 25.0832
R1_2 VSS VSS:16 25.0832
R1_3 VSS VSS:29 31.764
R1_4 M1:SRC VSS:25 30000.0
R1_5 M1:SRC VSS:10 30000.0
R1_6 M1:SRC VSS:37 15000.0
R1_7 M2:DRN VSS:25 30000.0
R1_8 M2:DRN VSS:10 30000.0
R1_9 M2:DRN VSS:37 15000.0
R1_10 M3:SRC VSS:24 30000.0
R1_11 M3:SRC VSS:9 30000.0
R1_12 M3:SRC VSS:35 15000.0
R1_13 M4:DRN VSS:24 30000.0
R1_14 M4:DRN VSS:9 30000.0
R1_15 M4:DRN VSS:35 15000.0
R1_16 M5:SRC VSS:23 30000.0
R1_17 M5:SRC VSS:8 30000.0
R1_18 M5:SRC VSS:33 15000.0
R1_19 M6:DRN VSS:23 30000.0
R1_20 M6:DRN VSS:8 30000.0
R1_21 M6:DRN VSS:33 15000.0
R1_22 VSS:8 VSS:33 7.84041
R1_23 VSS:8 VSS:30 12.4587
R1_24 VSS:9 VSS:35 7.84041
R1_25 VSS:9 VSS:29 12.4587
R1_26 VSS:10 VSS:37 7.84041
R1_27 VSS:10 VSS:19 12.4587
R1_28 VSS:11 VSS:12 63.5281
R1_29 VSS:11 VSS:28 17.9166
R1_30 VSS:11 VSS:13 25.0832
R1_31 VSS:12 VSS:31 39.6198
R1_32 VSS:12 VSS:30 50.1851
R1_33 VSS:13 VSS:14 25.0832
R1_34 VSS:13 VSS:30 31.764
R1_35 VSS:14 VSS:15 63.5281
R1_36 VSS:15 VSS:30 50.1851
R1_37 VSS:15 VSS:29 50.1851
R1_38 VSS:16 VSS:17 63.5281
R1_39 VSS:16 VSS:18 25.0832
R1_40 VSS:17 VSS:29 50.1851
R1_41 VSS:17 VSS:19 50.1851
R1_42 VSS:18 VSS:19 31.764
R1_43 VSS:18 VSS:20 25.0832
R1_44 VSS:19 VSS:21 50.1851
R1_45 VSS:20 VSS:21 63.5281
R1_46 VSS:20 VSS:39 17.9166
R1_47 VSS:21 VSS:32 39.6198
R1_48 VSS:22 VSS:26 7778.54
R1_49 VSS:23 VSS:33 7.84041
R1_50 VSS:23 VSS:34 1.77981
R1_51 VSS:24 VSS:35 7.84041
R1_52 VSS:24 VSS:36 1.77981
R1_53 VSS:25 VSS:38 1.77981
R1_54 VSS:25 VSS:37 7.84041
R1_55 VSS:26 VSS:27 4527.44
R1_56 VSS:12 VSS:22 0.01

*|NET VDD 5.52647e-05PF
*|P (VDD B 0 0.1470 0.1440)
*|I (M11:SRC M11 SRC B 0 0.0780 0.1080)
*|I (M12:DRN M12 DRN B 0 0.0480 0.1080)
C2_1 VDD VSS:19 7.80663e-20
C2_2 VDD:8 VSS:19 3.83957e-20
C2_3 VDD VSS:22 1.59435e-18
C2_4 VDD:4 VSS:22 8.02187e-19
C2_5 VDD:8 VSS:22 1.50445e-18
C2_6 VDD VSS:28 5.92315e-19
C2_7 VDD:8 VSS:28 2.76282e-20
C2_8 VDD:8 VSS:30 4.65622e-19
C2_9 VDD:19 VSS:30 2.24891e-20
Cg2_10 VDD VSS 9.721e-18
Cg2_11 VDD:4 VSS 2.84973e-19
Cg2_12 VDD:8 VSS 1.67583e-17
R2_1 VDD VDD:9 25.0832
R2_2 VDD VDD:11 63.5281
R2_3 VDD VDD:12 25.0832
R2_4 VDD VDD:18 55973.3
R2_5 M11:SRC VDD:19 30000.0
R2_6 M11:SRC VDD:4 30000.0
R2_7 M11:SRC VDD:22 15000.0
R2_8 M12:DRN VDD:19 30000.0
R2_9 M12:DRN VDD:4 30000.0
R2_10 M12:DRN VDD:22 15000.0
R2_11 VDD:4 VDD:22 7.84041
R2_12 VDD:4 VDD:23 1.77981
R2_13 VDD:5 VDD:6 63.5281
R2_14 VDD:5 VDD:24 17.9166
R2_15 VDD:5 VDD:7 25.0832
R2_16 VDD:6 VDD:20 39.6198
R2_17 VDD:6 VDD:8 50.1851
R2_18 VDD:7 VDD:8 31.764
R2_19 VDD:7 VDD:9 25.0832
R2_20 VDD:8 VDD:10 50.1851
R2_21 VDD:8 VDD:19 12.4587
R2_22 VDD:9 VDD:10 63.5281
R2_23 VDD:10 VDD:11 55.4677
R2_24 VDD:11 VDD:13 55.4677
R2_25 VDD:12 VDD:13 63.5281
R2_26 VDD:12 VDD:14 25.0832
R2_27 VDD:13 VDD:15 55.4677
R2_28 VDD:14 VDD:15 63.5281
R2_29 VDD:14 VDD:16 25.0832
R2_30 VDD:15 VDD:17 55.4677
R2_31 VDD:16 VDD:17 63.5281
R2_32 VDD:16 VDD:25 17.9166
R2_33 VDD:17 VDD:21 39.6198
R2_34 VDD:19 VDD:22 7.84041

*|NET Y 7.70391e-05PF
*|P (Y B 0 0.1470 0.0288)
*|I (M1:DRN M1 DRN B 0 0.2580 0.0360)
*|I (M2:SRC M2 SRC B 0 0.2040 0.0360)
*|I (M3:DRN M3 DRN B 0 0.1740 0.0360)
*|I (M4:SRC M4 SRC B 0 0.1200 0.0360)
*|I (M5:DRN M5 DRN B 0 0.0900 0.0360)
*|I (M6:SRC M6 SRC B 0 0.0360 0.0360)
*|I (M8:SRC M8 SRC B 0 0.2040 0.1080)
*|I (M9:DRN M9 DRN B 0 0.1740 0.1080)
C3_1 M5:DRN VSS:8 3.18486e-20
C3_2 Y:27 VSS:8 2.14342e-19
C3_3 M3:DRN VSS:9 3.00786e-20
C3_4 Y:27 VSS:9 2.25446e-19
C3_5 M1:DRN VSS:10 2.91132e-20
C3_6 Y:27 VSS:10 1.28994e-19
C3_7 Y:28 VSS:10 2.6027e-20
C3_8 M1:DRN VSS:19 1.21224e-19
C3_9 M3:DRN VSS:19 2.38376e-20
C3_10 M5:DRN VSS:19 2.08949e-20
C3_11 M6:SRC VSS:19 3.48249e-21
C3_12 Y:10 VSS:19 1.93254e-18
C3_13 Y:11 VSS:19 2.31904e-18
C3_14 Y:12 VSS:19 2.32821e-18
C3_15 Y:13 VSS:19 2.51257e-18
C3_16 Y:14 VSS:19 5.50499e-20
C3_17 Y:27 VSS:19 1.65885e-18
C3_18 Y:28 VSS:19 3.11667e-20
C3_19 Y:10 VSS:22 1.06728e-18
C3_20 Y:11 VSS:22 1.07818e-18
C3_21 Y:12 VSS:22 9.05188e-19
C3_22 Y:14 VSS:22 8.02241e-19
C3_23 Y:15 VSS:22 8.01794e-19
C3_24 Y:17 VSS:22 8.01327e-19
C3_25 Y:27 VSS:22 1.1927e-18
C3_26 Y:28 VSS:22 4.14542e-19
C3_27 Y:10 VSS:23 2.47523e-20
C3_28 Y:14 VSS:23 3.00786e-20
C3_29 Y:27 VSS:23 5.03491e-20
C3_30 Y:11 VSS:24 2.47523e-20
C3_31 Y:15 VSS:24 3.00786e-20
C3_32 Y:27 VSS:24 4.44867e-20
C3_33 Y:12 VSS:25 2.86804e-20
C3_34 Y:16 VSS:25 2.91132e-20
C3_35 Y:27 VSS:25 5.36728e-20
C3_36 Y:12 VSS:26 1.80397e-19
C3_37 Y:27 VSS:26 1.1863e-19
C3_38 Y:27 VSS:27 1.40251e-19
C3_39 Y:28 VSS:27 1.33651e-19
C3_40 Y:10 VSS:28 1.59426e-19
C3_41 Y:11 VSS:28 1.03333e-19
C3_42 Y:12 VSS:28 9.92839e-20
C3_43 Y:13 VSS:28 1.06747e-19
C3_44 Y:27 VSS:28 1.77527e-17
C3_45 Y:28 VSS:28 9.36402e-20
C3_46 M3:DRN VSS:29 2.47523e-20
C3_47 Y:27 VSS:29 3.77371e-19
C3_48 M5:DRN VSS:30 2.80042e-20
C3_49 Y:27 VSS:30 3.5893e-19
Cg3_50 Y:10 VSS 4.36656e-19
Cg3_51 Y:11 VSS 3.35906e-19
Cg3_52 Y:12 VSS 2.2041e-18
Cg3_53 Y:13 VSS 3.1662e-19
Cg3_54 Y:14 VSS 2.63917e-19
Cg3_55 Y:15 VSS 2.27812e-19
Cg3_56 Y:16 VSS 2.39118e-19
Cg3_57 Y:17 VSS 2.67001e-19
Cg3_58 Y:18 VSS 1.78742e-19
Cg3_59 Y:27 VSS 3.34176e-18
Cg3_60 Y:28 VSS 1.91549e-18
R3_1 Y Y:23 25.0832
R3_2 Y Y:21 25.0832
R3_3 M1:DRN Y:18 30000.0
R3_4 M1:DRN Y:13 30000.0
R3_5 M1:DRN Y:26 15000.0
R3_6 M2:SRC Y:29 30000.0
R3_7 M2:SRC Y:32 20270.3
R3_8 M2:SRC Y:16 57692.3
R3_9 M2:SRC Y:24 30000.0
R3_10 M3:DRN Y:29 30000.0
R3_11 M3:DRN Y:32 20270.3
R3_12 M3:DRN Y:16 57692.3
R3_13 M3:DRN Y:24 30000.0
R3_14 M4:SRC Y:15 30000.0
R3_15 M4:SRC Y:31 20270.3
R3_16 M4:SRC Y:11 57692.3
R3_17 M4:SRC Y:22 30000.0
R3_18 M5:DRN Y:15 30000.0
R3_19 M5:DRN Y:31 20270.3
R3_20 M5:DRN Y:11 57692.3
R3_21 M5:DRN Y:22 30000.0
R3_22 M6:SRC Y:14 30000.0
R3_23 M6:SRC Y:30 20270.3
R3_24 M6:SRC Y:10 57692.3
R3_25 M6:SRC Y:20 30000.0
R3_26 M8:SRC Y:17 30000.0
R3_27 M8:SRC Y:12 30000.0
R3_28 M8:SRC Y:33 15000.0
R3_29 M9:DRN Y:17 30000.0
R3_30 M9:DRN Y:12 30000.0
R3_31 M9:DRN Y:33 15000.0
R3_32 Y:10 Y:20 5.51688
R3_33 Y:11 Y:22 5.51634
R3_34 Y:12 Y:17 18.6881
R3_35 Y:12 Y:29 24.9174
R3_36 Y:12 Y:33 7.84041
R3_37 Y:13 Y:26 9.78801
R3_38 Y:14 Y:20 14.0605
R3_39 Y:14 Y:30 98999.9
R3_40 Y:15 Y:22 14.0605
R3_41 Y:15 Y:31 49500.0
R3_42 Y:16 Y:24 5.51634
R3_43 Y:17 Y:33 49500.0
R3_44 Y:18 Y:26 9.78801
R3_45 Y:19 Y:20 63.5281
R3_46 Y:19 Y:34 3.58332
R3_47 Y:19 Y:21 50.1665
R3_48 Y:20 Y:30 3.76373
R3_49 Y:21 Y:22 63.5281
R3_50 Y:22 Y:31 3.7634
R3_51 Y:23 Y:24 63.5281
R3_52 Y:23 Y:27 50.1665
R3_53 Y:24 Y:29 13.1706
R3_54 Y:24 Y:32 3.7634
R3_55 Y:25 Y:26 63.5281
R3_56 Y:25 Y:27 4.29998
R3_57 Y:25 Y:28 34.3401
R3_58 Y:29 Y:32 45000.0

*|NET A 1.86354e-05PF
*|P (A B 0 0.0630 0.0720)
*|I (M11:GATE M11 GATE I 3.6e-19 0.0840 0.1080)
*|I (M12:GATE M12 GATE I 3.6e-19 0.0420 0.1080)
*|I (M5:GATE M5 GATE I 3.6e-19 0.0840 0.0360)
*|I (M6:GATE M6 GATE I 3.6e-19 0.0420 0.0360)
C4_1 A:6 VSS:19 4.59524e-19
C4_2 A:7 VSS:19 7.89427e-21
C4_3 A:11 VSS:19 4.59524e-19
C4_4 A:12 VSS:19 7.89427e-21
C4_5 A:20 VSS:22 1.87272e-19
C4_6 A:21 VSS:22 2.51868e-19
C4_7 A:22 VSS:22 1.98867e-19
C4_8 A:20 VSS:28 1.38275e-19
C4_9 A:21 VSS:28 2.78732e-19
C4_10 A:21 VSS:30 3.06792e-19
C4_11 A:10 VDD 4.17741e-20
C4_12 A:15 VDD 4.17741e-20
C4_13 A:21 VDD 2.78732e-19
C4_14 A:22 VDD 1.38275e-19
C4_15 A:10 VDD:8 1.15217e-19
C4_16 A:15 VDD:8 1.15217e-19
C4_17 A:21 VDD:8 6.63905e-20
C4_18 A:20 M6:SRC 1.44074e-20
C4_19 A:20 Y:10 4.46103e-19
C4_20 A:21 Y:10 7.8262e-21
C4_21 A:20 Y:14 2.03074e-21
C4_22 A:6 Y:27 2.82147e-20
C4_23 A:7 Y:27 6.1289e-20
C4_24 A:11 Y:27 3.44233e-20
C4_25 A:12 Y:27 9.30183e-20
C4_26 A:20 Y:27 1.48058e-18
C4_27 A:21 Y:27 2.47628e-18
Cg4_28 A:6 VSS 1.09775e-19
Cg4_29 A:8 VSS 3.4119e-19
Cg4_30 A:10 VSS 2.27134e-19
Cg4_31 A:11 VSS 1.09775e-19
Cg4_32 A:13 VSS 3.4119e-19
Cg4_33 A:15 VSS 2.27134e-19
Cg4_34 A:17 VSS 7.39304e-20
Cg4_35 A:19 VSS 7.39304e-20
Cg4_36 A:20 VSS 8.70973e-19
Cg4_37 A:21 VSS 1.33162e-18
Cg4_38 A:22 VSS 9.28103e-19
R4_1 A A:18 12.5416
R4_2 A A:16 12.5416
R4_3 M11:GATE A:14 7.57576
R4_4 M11:GATE A:13 7.57576
R4_5 M12:GATE A:9 7.57576
R4_6 M12:GATE A:8 7.57576
R4_7 M5:GATE A:12 7.57576
R4_8 M5:GATE A:11 7.57576
R4_9 M6:GATE A:7 7.57576
R4_10 M6:GATE A:6 7.57576
R4_11 A:6 A:23 5.55556
R4_12 A:7 A:17 10.6061
R4_13 A:8 A:17 10.6061
R4_14 A:9 A:10 5.55556
R4_15 A:11 A:24 5.55556
R4_16 A:12 A:19 10.6061
R4_17 A:13 A:19 10.6061
R4_18 A:14 A:15 5.55556
R4_19 A:16 A:17 63.5281
R4_20 A:16 A:20 12.5416
R4_21 A:18 A:19 63.5281
R4_22 A:18 A:21 3.58332
R4_23 A:20 A:22 12.8402
R4_24 A:20 A:25 12.8402

*|NET C 3.23286e-05PF
*|P (C B 0 0.1680 0.0575)
*|I (M10:GATE M10 GATE I 3.6e-19 0.1260 0.1080)
*|I (M2:GATE M2 GATE I 3.6e-19 0.2100 0.0360)
*|I (M4:GATE M4 GATE I 3.6e-19 0.1260 0.0360)
*|I (M8:GATE M8 GATE I 3.6e-19 0.2100 0.1080)
C5_1 C:20 VSS:8 2.97956e-20
C5_2 C:18 VSS:9 1.40094e-20
C5_3 C:20 VSS:9 1.45968e-20
C5_4 C:6 VSS:19 4.59524e-19
C5_5 C:7 VSS:19 7.89427e-21
C5_6 C:11 VSS:19 5.61697e-19
C5_7 C:12 VSS:19 7.89427e-21
C5_8 C:18 VSS:22 1.52698e-19
C5_9 C:20 VSS:22 4.67226e-19
C5_10 C:21 VSS:22 3.54419e-19
C5_11 C:20 VSS:24 1.75327e-21
C5_12 C:18 VSS:25 8.11324e-21
C5_13 C:20 VSS:25 5.07078e-22
C5_14 C:18 VSS:26 7.93983e-20
C5_15 C:11 VSS:28 2.5889e-20
C5_16 C:18 VSS:28 1.56099e-19
C5_17 C:20 VSS:28 5.01598e-19
C5_18 C:18 VSS:29 1.53768e-20
C5_19 C:20 VSS:29 5.30125e-19
C5_20 C:20 VSS:30 8.04913e-20
C5_21 C:18 M3:DRN 3.23714e-20
C5_22 C:20 M3:DRN 2.8288e-20
C5_23 C:20 M5:DRN 1.45846e-21
C5_24 C:20 Y:11 1.85854e-19
C5_25 C:12 Y:12 6.86157e-19
C5_26 C:13 Y:12 9.5874e-19
C5_27 C:18 Y:12 6.84112e-20
C5_28 C:20 Y:12 5.23202e-19
C5_29 C:20 Y:15 4.92877e-20
C5_30 C:12 Y:16 1.21898e-18
C5_31 C:18 Y:16 2.2542e-20
C5_32 C:20 Y:16 1.45968e-20
C5_33 C:6 Y:27 2.82147e-20
C5_34 C:7 Y:27 5.37599e-20
C5_35 C:11 Y:27 9.96357e-21
C5_36 C:12 Y:27 6.19746e-20
C5_37 C:13 Y:27 6.60424e-20
C5_38 C:18 Y:27 1.67821e-18
C5_39 C:20 Y:27 5.72799e-18
C5_40 C:21 Y:27 8.72731e-20
C5_41 C:18 Y:28 1.30692e-19
C5_42 C:20 Y:28 8.72063e-20
C5_43 C:18 A:20 4.47476e-20
C5_44 C:20 A:20 3.5669e-19
C5_45 C:21 A:20 2.92238e-20
C5_46 C:18 A:21 1.5159e-20
C5_47 C:20 A:21 9.89926e-20
C5_48 C:21 A:21 7.16932e-19
C5_49 C:21 A:22 3.47649e-19
Cg5_50 C:6 VSS 1.09775e-19
Cg5_51 C:8 VSS 3.4119e-19
Cg5_52 C:10 VSS 3.84125e-19
Cg5_53 C:11 VSS 2.08947e-19
Cg5_54 C:13 VSS 3.4119e-19
Cg5_55 C:15 VSS 3.84125e-19
Cg5_56 C:17 VSS 7.07805e-20
Cg5_57 C:18 VSS 3.80954e-19
Cg5_58 C:19 VSS 1.04259e-19
Cg5_59 C:20 VSS 1.14036e-18
Cg5_60 C:21 VSS 8.0463e-19
R5_1 C C:18 20.1154
R5_2 C C:20 20.1154
R5_3 M10:GATE C:9 7.57576
R5_4 M10:GATE C:8 7.57576
R5_5 M2:GATE C:12 7.57576
R5_6 M2:GATE C:11 7.57576
R5_7 M4:GATE C:7 7.57576
R5_8 M4:GATE C:6 7.57576
R5_9 M8:GATE C:14 7.57576
R5_10 M8:GATE C:13 7.57576
R5_11 C:6 C:22 5.55556
R5_12 C:7 C:17 10.6061
R5_13 C:8 C:17 10.6061
R5_14 C:9 C:10 5.55556
R5_15 C:11 C:23 5.55556
R5_16 C:12 C:19 3.28283
R5_17 C:13 C:19 17.9293
R5_18 C:14 C:15 5.55556
R5_19 C:16 C:17 63.5281
R5_20 C:16 C:20 8.06247
R5_21 C:16 C:21 12.8402
R5_22 C:18 C:19 63.5281

*|NET B 3.31315e-05PF
*|P (B B 0 0.2100 0.0865)
*|I (M1:GATE M1 GATE I 3.6e-19 0.2520 0.0360)
*|I (M3:GATE M3 GATE I 3.6e-19 0.1680 0.0360)
*|I (M7:GATE M7 GATE I 3.6e-19 0.2520 0.1080)
*|I (M9:GATE M9 GATE I 3.6e-19 0.1680 0.1080)
C6_1 B:12 VSS:10 1.22647e-18
C6_2 B:22 VSS:10 2.68029e-20
C6_3 B:6 VSS:19 4.59524e-19
C6_4 B:7 VSS:19 7.89427e-21
C6_5 B:11 VSS:19 4.59524e-19
C6_6 B:12 VSS:19 6.94835e-19
C6_7 B:13 VSS:19 1.84676e-19
C6_8 B:16 VSS:19 4.50708e-19
C6_9 B:21 VSS:19 1.01181e-19
C6_10 B:22 VSS:19 3.29198e-19
C6_11 B:16 VSS:22 4.95591e-21
C6_12 B:17 VSS:22 1.01415e-19
C6_13 B:21 VSS:22 3.5855e-19
C6_14 B:22 VSS:22 1.61172e-19
C6_15 B:11 VSS:28 4.13342e-20
C6_16 B:21 VSS:28 3.83914e-20
C6_17 B:22 VSS:28 1.28635e-19
C6_18 B:17 M9:DRN 2.33354e-20
C6_19 B:21 M9:DRN 2.71963e-20
C6_20 B:21 Y:12 4.33883e-19
C6_21 B:22 Y:12 6.15482e-21
C6_22 B:21 Y:17 1.45968e-20
C6_23 B:6 Y:27 3.56347e-20
C6_24 B:7 Y:27 8.2457e-20
C6_25 B:12 Y:27 5.53559e-20
C6_26 B:13 Y:27 8.21899e-20
C6_27 B:17 Y:27 1.35428e-19
C6_28 B:21 Y:27 4.05474e-19
C6_29 B:22 Y:27 1.52689e-18
C6_30 B:12 Y:28 1.02133e-19
C6_31 B:13 Y:28 2.0538e-19
C6_32 B:14 Y:28 1.83857e-20
C6_33 B:16 Y:28 1.94655e-19
C6_34 B:17 Y:28 9.55693e-20
C6_35 B:21 Y:28 1.05256e-18
C6_36 B:22 Y:28 1.89941e-18
C6_37 B:11 C:11 3.12363e-20
C6_38 B:21 C:13 4.28987e-20
C6_39 B:21 C:14 1.2639e-21
C6_40 B:21 C:18 1.83026e-18
C6_41 B:22 C:18 6.92222e-19
C6_42 B:21 C:19 1.51495e-20
C6_43 B:7 C:20 1.2639e-21
C6_44 B:8 C:20 6.74855e-20
C6_45 B:17 C:20 1.79658e-18
C6_46 B:21 C:20 1.62308e-18
C6_47 B:22 C:20 1.12898e-18
C6_48 B:17 C:21 5.09349e-19
C6_49 B:21 C:21 8.15744e-19
C6_50 B:22 C:21 2.21837e-20
Cg6_51 B:6 VSS 1.09775e-19
Cg6_52 B:8 VSS 3.4119e-19
Cg6_53 B:10 VSS 3.84125e-19
Cg6_54 B:11 VSS 1.00945e-19
Cg6_55 B:13 VSS 9.79752e-19
Cg6_56 B:15 VSS 4.36985e-19
Cg6_57 B:16 VSS 4.46516e-19
Cg6_58 B:17 VSS 7.1524e-19
Cg6_59 B:18 VSS 4.71178e-20
Cg6_60 B:21 VSS 1.44143e-18
Cg6_61 B:22 VSS 5.01243e-19
R6_1 B B:21 14.8471
R6_2 B B:17 20.1154
R6_3 M1:GATE B:12 7.57576
R6_4 M1:GATE B:11 7.57576
R6_5 M3:GATE B:7 7.57576
R6_6 M3:GATE B:6 7.57576
R6_7 M7:GATE B:14 7.57576
R6_8 M7:GATE B:13 7.57576
R6_9 M9:GATE B:9 7.57576
R6_10 M9:GATE B:8 7.57576
R6_11 B:6 B:23 5.55556
R6_12 B:7 B:18 17.9293
R6_13 B:8 B:18 3.28283
R6_14 B:9 B:10 5.55556
R6_15 B:11 B:24 5.55556
R6_16 B:12 B:16 10.6061
R6_17 B:13 B:16 10.6061
R6_18 B:14 B:15 5.55556
R6_19 B:16 B:20 14.5273
R6_20 B:17 B:18 63.5281
R6_21 B:19 B:20 63.5281
R6_22 B:19 B:22 12.8402
R6_23 B:19 B:21 8.06247
R6_24 B:20 B:25 7.92396

*|NET 11 4.4165e-07PF
*|I (M10:SRC M10 SRC B 0 0.1200 0.1080)
*|I (M11:DRN M11 DRN B 0 0.0900 0.1080)
C8_1 M11:DRN VDD 6.89912e-20
C8_2 M11:DRN VDD:4 3.18808e-20
C8_3 M11:DRN VDD:8 2.80634e-20
C8_4 M11:DRN Y:11 1.83418e-19
C8_5 M11:DRN C:21 1.60431e-20
R8_1 M10:SRC M11:DRN 15000.0

*|NET 12 4.68962e-07PF
*|I (M10:DRN M10 DRN B 0 0.1320 0.1080)
*|I (M9:SRC M9 SRC B 0 0.1620 0.1080)
C9_1 M10:DRN VSS:29 1.84954e-19
C9_2 M10:DRN VDD 1.03708e-19
C9_3 M10:DRN C:20 5.26208e-20
C9_4 M10:DRN C:21 4.42117e-21
Cg9_5 M10:DRN VSS 1.19839e-20
R9_1 M10:DRN M9:SRC 15000.0

*|NET 13 5.91552e-07PF
*|I (M7:SRC M7 SRC B 0 0.2460 0.1080)
*|I (M8:DRN M8 DRN B 0 0.2160 0.1080)
C10_1 M8:DRN VSS:19 1.16875e-19
C10_2 M8:DRN VDD 9.56961e-20
C10_3 M8:DRN Y:12 2.30376e-20
C10_4 M8:DRN Y:17 2.91454e-20
C10_5 M8:DRN B:16 1.73519e-19
C10_6 M8:DRN B:21 3.0594e-20
R10_1 M7:SRC M8:DRN 15000.0

*|NET 5 5.01385e-05PF
*|I (M12:SRC M12 SRC B 0 0.0360 0.1080)
*|I (M7:DRN M7 DRN B 0 0.2580 0.1080)
C11_1 M12:SRC VSS:19 6.39342e-21
C11_2 5:3 VSS:19 6.28053e-20
C11_3 5:3 VSS:22 1.06735e-18
C11_4 5:5 VSS:22 8.02277e-19
C11_5 5:11 VSS:22 1.54224e-18
C11_6 5:11 VSS:28 5.39002e-20
C11_7 5:3 VDD 2.97907e-19
C11_8 5:4 VDD 2.07556e-19
C11_9 5:11 VDD 1.8061e-17
C11_10 5:11 VDD:4 2.14209e-19
C11_11 5:3 VDD:8 1.4613e-18
C11_12 5:4 VDD:8 1.06277e-18
C11_13 5:11 VDD:8 3.58938e-19
C11_14 5:3 VDD:19 2.48114e-20
C11_15 5:5 VDD:19 3.01108e-20
C11_16 5:11 VDD:19 5.03619e-20
C11_17 5:11 M9:DRN 5.01507e-20
C11_18 M12:SRC Y:10 2.45598e-20
C11_19 5:3 Y:10 5.71699e-19
C11_20 5:11 Y:11 1.00004e-19
C11_21 5:11 Y:12 4.24564e-19
C11_22 M7:DRN Y:13 1.74534e-20
C11_23 5:4 Y:13 3.70946e-19
C11_24 5:11 Y:13 1.47951e-20
C11_25 5:11 Y:17 2.57131e-19
C11_26 5:11 Y:27 1.04554e-18
C11_27 5:4 Y:28 1.08679e-19
C11_28 5:11 Y:28 1.62598e-18
C11_29 5:11 A:9 6.13044e-20
C11_30 5:11 A:10 1.9335e-20
C11_31 5:11 A:14 9.30494e-20
C11_32 5:11 A:15 2.55221e-20
C11_33 5:11 A:17 2.61448e-20
C11_34 5:11 A:19 2.61448e-20
C11_35 5:3 A:21 7.82953e-21
C11_36 5:11 A:21 2.48934e-18
C11_37 M12:SRC A:22 1.64111e-20
C11_38 5:3 A:22 1.27657e-19
C11_39 5:5 A:22 2.03074e-21
C11_40 5:11 A:22 1.47206e-18
C11_41 5:11 C:9 5.09766e-20
C11_42 5:11 C:10 1.9335e-20
C11_43 5:11 C:14 5.37777e-20
C11_44 5:11 C:15 1.9335e-20
C11_45 5:11 C:17 1.45151e-20
C11_46 5:11 C:18 1.63183e-19
C11_47 5:11 C:20 7.77371e-19
C11_48 5:11 C:21 1.5093e-18
C11_49 5:11 B:9 8.0837e-20
C11_50 5:11 B:10 2.67294e-20
C11_51 5:11 B:13 9.08279e-20
C11_52 5:11 B:14 5.79949e-20
C11_53 5:11 B:15 3.14075e-20
C11_54 5:11 B:16 1.63991e-20
C11_55 5:11 B:17 1.70915e-18
C11_56 5:11 B:21 4.9906e-18
C11_57 5:11 B:22 9.51075e-20
C11_58 5:11 M11:DRN 1.13254e-19
C11_59 5:11 M10:DRN 1.11274e-19
C11_60 5:11 M8:DRN 1.22685e-19
Cg11_61 M12:SRC VSS 5.43919e-21
Cg11_62 5:3 VSS 3.69611e-19
Cg11_63 5:4 VSS 2.85363e-19
Cg11_64 5:5 VSS 2.64174e-19
Cg11_65 5:6 VSS 1.78742e-19
Cg11_66 5:11 VSS 3.8148e-18
R11_1 M12:SRC 5:3 30000.0
R11_2 M12:SRC 5:12 20089.3
R11_3 M12:SRC 5:5 59210.5
R11_4 M12:SRC 5:8 30000.0
R11_5 M7:DRN 5:4 30000.0
R11_6 M7:DRN 5:13 20089.3
R11_7 M7:DRN 5:6 59210.5
R11_8 M7:DRN 5:10 30000.0
R11_9 5:3 5:8 14.1199
R11_10 5:3 5:12 8.62521
R11_11 5:4 5:10 14.1199
R11_12 5:4 5:13 8.62521
R11_13 5:5 5:8 5.45756
R11_14 5:6 5:10 5.45756
R11_15 5:7 5:8 63.5281
R11_16 5:7 5:11 3.58332
R11_17 5:7 5:9 150.499
R11_18 5:8 5:12 43800.0
R11_19 5:9 5:10 63.5281
R11_20 5:9 5:14 3.58332
R11_21 5:10 5:13 43800.0

*|NET _generated_14 2.86064e-06PF
C12_1 _generated_14:1 VSS:22 6.59899e-19
C12_2 _generated_14:1 VSS:28 2.25577e-20
C12_3 _generated_14:1 Y:10 3.44454e-19
C12_4 _generated_14:1 Y:27 1.63932e-19
C12_5 _generated_14:1 A:20 1.35335e-19
Cg12_6 _generated_14:1 VSS 9.5542e-19
R12_1 _generated_14:1 _generated_14:2 28.2828

*|NET _generated_15 3.14009e-06PF
C13_1 _generated_15:1 VSS:19 1.47021e-19
C13_2 _generated_15:1 VSS:22 6.5598e-19
C13_3 _generated_15:1 VDD 5.00228e-20
C13_4 _generated_15:1 VDD:8 1.18927e-19
C13_5 _generated_15:1 A:22 1.50877e-19
C13_6 _generated_15:1 5:3 3.4564e-19
C13_7 _generated_15:1 5:11 1.56492e-19
C13_8 _generated_15:1 _generated_14:1 5.79044e-19
Cg13_9 _generated_15:1 VSS 9.3608e-19
R13_1 _generated_15:1 _generated_15:2 28.2828

*|NET _generated_16 5.34131e-06PF
C14_1 _generated_16:1 VSS:19 4.72309e-19
C14_2 _generated_16:1 VSS:22 2.98844e-20
C14_3 _generated_16:1 VSS:28 9.68154e-20
C14_4 _generated_16:1 Y:13 3.81915e-19
C14_5 _generated_16:1 Y:28 6.34401e-20
C14_6 _generated_16:1 B:11 4.75026e-20
C14_7 _generated_16:1 B:13 2.39654e-19
Cg14_8 _generated_16:1 VSS 3.40563e-18
R14_1 _generated_16:1 _generated_16:2 28.2828

*|NET _generated_17 4.96288e-06PF
C15_1 _generated_17:1 VDD 1.91825e-19
C15_2 _generated_17:1 VDD:8 1.19386e-19
C15_3 _generated_17:1 B:13 2.39654e-19
C15_4 _generated_17:1 B:15 4.75026e-20
C15_5 _generated_17:1 5:4 3.81915e-19
C15_6 _generated_17:1 _generated_16:1 6.0415e-19
Cg15_7 _generated_17:1 VSS 3.37844e-18
R15_1 _generated_17:1 _generated_17:2 28.2828

*
* Instance Section
*
MM1 M1:DRN M1:GATE M1:SRC VSS NMOS_LVT l=0.012u w=0.03u NF=1
MM10 M10:DRN M10:GATE M10:SRC VDD PMOS_LVT l=0.012u w=0.03u NF=1
MM11 M11:DRN M11:GATE M11:SRC VDD PMOS_LVT l=0.012u w=0.03u NF=1
MM12 M12:DRN M12:GATE M12:SRC VDD PMOS_LVT l=0.012u w=0.03u NF=1
MM2 M2:DRN M2:GATE M2:SRC VSS NMOS_LVT l=0.012u w=0.03u NF=1
MM3 M3:DRN M3:GATE M3:SRC VSS NMOS_LVT l=0.012u w=0.03u NF=1
MM4 M4:DRN M4:GATE M4:SRC VSS NMOS_LVT l=0.012u w=0.03u NF=1
MM5 M5:DRN M5:GATE M5:SRC VSS NMOS_LVT l=0.012u w=0.03u NF=1
MM6 M6:DRN M6:GATE M6:SRC VSS NMOS_LVT l=0.012u w=0.03u NF=1
MM7 M7:DRN M7:GATE M7:SRC VDD PMOS_LVT l=0.012u w=0.03u NF=1
MM8 M8:DRN M8:GATE M8:SRC VDD PMOS_LVT l=0.012u w=0.03u NF=1
MM9 M9:DRN M9:GATE M9:SRC VDD PMOS_LVT l=0.012u w=0.03u NF=1

.ENDS
