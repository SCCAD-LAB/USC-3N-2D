*
*|DSPF 1.3
*|DESIGN OAI221x1
*|DATE "Tue Nov  3 20:53:45 2026"
*|VENDOR "Synopsys"
*|PROGRAM "StarRC"
*|VERSION "X-2025.06-SP1"
*|DIVIDER /
*|DELIMITER :
**FORMAT SPF
*

** COMMENTS

** OPERATING_TEMPERATURE 25
** GLOBAL_TEMPERATURE 25
**
** TCAD_GRD_FILE /cedar/cedar_coe/ece-limsk/yhuang861/GRO/.planning/experiments_migrated_20261022/usc144_github_release_20261103/sources/github_FSPR.nxtgrd
**   TCAD_TIME_STAMP Tue Mar 31 05:07:55 2026
**   TCADGRD_VERSION 89

.SUBCKT OAI221x1 VDD VSS Y A B E C D

*|GROUND_NET VSS

*|NET VDD 5.34121e-05PF
*|P (VDD B 0 0.1260 0.1440)
*|I (M10:SRC M10 SRC B 0 0.0360 0.1080)
*|I (M7:SRC M7 SRC B 0 0.1620 0.1080)
*|I (M8:DRN M8 DRN B 0 0.1320 0.1080)
Cg1_1 VDD VSS 8.79912e-18
Cg1_2 VDD:5 VSS 2.52098e-19
Cg1_3 VDD:6 VSS 2.41358e-19
Cg1_4 VDD:13 VSS 1.34496e-17
Cg1_5 VDD:18 VSS 1.38951e-20
Cg1_6 VDD:21 VSS 3.84624e-21
Cg1_7 VDD:23 VSS 1.0202e-18
R1_1 VDD VDD:10 12.5416
R1_2 VDD VDD:12 12.5416
R1_3 VDD VDD:20 0.1
R1_4 M10:SRC VDD:18 30000.0
R1_5 M10:SRC VDD:5 30000.0
R1_6 M10:SRC VDD:26 15000.0
R1_7 M7:SRC VDD:21 30000.0
R1_8 M7:SRC VDD:6 30000.0
R1_9 M7:SRC VDD:28 15000.0
R1_10 M8:DRN VDD:21 30000.0
R1_11 M8:DRN VDD:6 30000.0
R1_12 M8:DRN VDD:28 15000.0
R1_13 VDD:5 VDD:26 7.8411
R1_14 VDD:5 VDD:27 1.77981
R1_15 VDD:6 VDD:28 7.84041
R1_16 VDD:6 VDD:29 1.77981
R1_17 VDD:7 VDD:30 17.9166
R1_18 VDD:7 VDD:8 25.0832
R1_19 VDD:7 VDD:23 31.764
R1_20 VDD:8 VDD:9 63.5281
R1_21 VDD:8 VDD:10 25.0832
R1_22 VDD:9 VDD:23 50.1851
R1_23 VDD:9 VDD:11 55.4677
R1_24 VDD:10 VDD:11 63.5281
R1_25 VDD:11 VDD:13 50.1851
R1_26 VDD:12 VDD:13 31.764
R1_27 VDD:12 VDD:14 25.0832
R1_28 VDD:13 VDD:15 50.1851
R1_29 VDD:13 VDD:21 12.4587
R1_30 VDD:14 VDD:15 63.5281
R1_31 VDD:14 VDD:16 25.0832
R1_32 VDD:15 VDD:17 55.4677
R1_33 VDD:16 VDD:17 63.5281
R1_34 VDD:16 VDD:31 17.9166
R1_35 VDD:17 VDD:25 39.6198
R1_36 VDD:18 VDD:26 7.8411
R1_37 VDD:18 VDD:23 12.4587
R1_38 VDD:19 VDD:20 18491.3
R1_39 VDD:20 VDD:22 29193.1
R1_40 VDD:21 VDD:28 7.84041
R1_41 VDD:23 VDD:24 34.3372

*|NET VSS 9.76513e-05PF
*|P (VSS B 0 0.1260 0.0000)
*|I (M4:SRC M4 SRC B 0 0.0780 0.0360)
*|I (M5:DRN M5 DRN B 0 0.0480 0.0360)
C2_1 VSS:8 VDD 7.79004e-20
C2_2 VSS:17 VDD 1.46147e-18
C2_3 VSS:21 VDD 6.78234e-19
C2_4 VSS:17 VDD:5 8.02586e-19
C2_5 VSS:17 VDD:6 8.00234e-19
C2_6 VSS:8 VDD:13 3.83957e-20
C2_7 VSS:17 VDD:13 1.31049e-18
C2_8 VSS:21 VDD:13 2.76282e-20
C2_9 VSS:8 VDD:18 6.69558e-21
C2_10 VSS:8 VDD:23 6.39263e-20
C2_11 VSS:17 VDD:23 1.49934e-18
Cg2_12 VSS:4 VSS 2.65379e-19
Cg2_13 VSS:8 VSS 2.4912e-18
Cg2_14 VSS:17 VSS 3.38231e-17
Cg2_15 VSS:19 VSS 4.3222e-18
Cg2_16 VSS:21 VSS 7.71722e-18
R2_1 VSS VSS:11 12.5416
R2_2 VSS VSS:9 12.5416
R2_3 M4:SRC VSS:18 30000.0
R2_4 M4:SRC VSS:4 30000.0
R2_5 M4:SRC VSS:24 15000.0
R2_6 M5:DRN VSS:18 30000.0
R2_7 M5:DRN VSS:4 30000.0
R2_8 M5:DRN VSS:24 15000.0
R2_9 VSS:4 VSS:24 7.84041
R2_10 VSS:4 VSS:8 12.4587
R2_11 VSS:5 VSS:6 63.5281
R2_12 VSS:5 VSS:21 17.9166
R2_13 VSS:5 VSS:7 25.0832
R2_14 VSS:6 VSS:22 39.6198
R2_15 VSS:6 VSS:8 50.1851
R2_16 VSS:7 VSS:8 31.764
R2_17 VSS:7 VSS:9 25.0832
R2_18 VSS:8 VSS:10 50.1851
R2_19 VSS:9 VSS:10 63.5281
R2_20 VSS:10 VSS:12 55.4677
R2_21 VSS:11 VSS:12 63.5281
R2_22 VSS:11 VSS:13 25.0832
R2_23 VSS:12 VSS:14 55.4677
R2_24 VSS:13 VSS:14 63.5281
R2_25 VSS:13 VSS:15 25.0832
R2_26 VSS:14 VSS:16 55.4677
R2_27 VSS:15 VSS:16 63.5281
R2_28 VSS:15 VSS:26 17.9166
R2_29 VSS:16 VSS:23 39.6198
R2_30 VSS:17 VSS:19 7778.54
R2_31 VSS:18 VSS:24 7.84041
R2_32 VSS:18 VSS:25 1.77981
R2_33 VSS:19 VSS:20 1966.46
R2_34 VSS:6 VSS:17 0.01

*|NET Y 4.67847e-05PF
*|P (Y B 0 0.1890 0.0720)
*|I (M1:SRC M1 SRC B 0 0.2040 0.0360)
*|I (M2:DRN M2 DRN B 0 0.1740 0.0360)
*|I (M6:DRN M6 DRN B 0 0.2160 0.1080)
*|I (M8:SRC M8 SRC B 0 0.1200 0.1080)
*|I (M9:DRN M9 DRN B 0 0.0900 0.1080)
C3_1 Y:7 VDD 1.92588e-19
C3_2 Y:9 VDD 2.1356e-19
C3_3 Y:19 VDD 9.77789e-18
C3_4 Y:20 VDD 5.06959e-20
C3_5 Y:19 VDD:6 1.57317e-19
C3_6 Y:20 VDD:6 4.96057e-20
C3_7 Y:7 VDD:13 1.19561e-18
C3_8 Y:9 VDD:13 1.06277e-18
C3_9 Y:19 VDD:13 6.12018e-19
C3_10 Y:20 VDD:13 7.82117e-20
C3_11 Y:7 VDD:21 2.48114e-20
C3_12 Y:10 VDD:21 3.01108e-20
C3_13 Y:19 VDD:21 5.39875e-20
C3_14 M2:DRN VSS:8 2.13404e-20
C3_15 Y:8 VSS:8 2.32971e-18
C3_16 Y:7 VSS:17 8.82123e-19
C3_17 Y:8 VSS:17 1.24263e-20
C3_18 Y:10 VSS:17 8.02037e-19
C3_19 Y:19 VSS:17 7.05982e-19
C3_20 Y:20 VSS:17 2.41991e-19
C3_21 Y:8 VSS:21 1.6294e-19
C3_22 Y:19 VSS:21 3.84286e-19
C3_23 Y:20 VSS:21 8.16394e-20
Cg3_24 M9:DRN VSS 3.52036e-21
Cg3_25 Y:7 VSS 4.63864e-19
Cg3_26 Y:8 VSS 4.34095e-19
Cg3_27 Y:9 VSS 2.84742e-19
Cg3_28 Y:10 VSS 2.55987e-19
Cg3_29 Y:11 VSS 2.63492e-19
Cg3_30 Y:12 VSS 1.78742e-19
Cg3_31 Y:19 VSS 2.25679e-18
Cg3_32 Y:20 VSS 1.11866e-18
R3_1 Y Y:19 25.8596
R3_2 Y Y:15 8.65969
R3_3 M1:SRC Y:11 30000.0
R3_4 M1:SRC Y:8 30000.0
R3_5 M1:SRC Y:23 15000.0
R3_6 M2:DRN Y:11 30000.0
R3_7 M2:DRN Y:8 30000.0
R3_8 M2:DRN Y:23 15000.0
R3_9 M6:DRN Y:9 30000.0
R3_10 M6:DRN Y:24 20089.3
R3_11 M6:DRN Y:12 59210.5
R3_12 M6:DRN Y:18 30000.0
R3_13 M8:SRC Y:7 30000.0
R3_14 M8:SRC Y:22 20089.3
R3_15 M8:SRC Y:10 59210.5
R3_16 M8:SRC Y:14 30000.0
R3_17 M9:DRN Y:7 30000.0
R3_18 M9:DRN Y:22 20089.3
R3_19 M9:DRN Y:10 59210.5
R3_20 M9:DRN Y:14 30000.0
R3_21 Y:7 Y:14 14.1199
R3_22 Y:7 Y:22 8.62446
R3_23 Y:8 Y:11 18.6881
R3_24 Y:8 Y:23 8.62446
R3_25 Y:9 Y:18 14.1199
R3_26 Y:9 Y:24 8.62521
R3_27 Y:10 Y:14 5.45702
R3_28 Y:11 Y:16 3.85627
R3_29 Y:11 Y:23 45000.0
R3_30 Y:12 Y:18 5.45756
R3_31 Y:13 Y:14 63.5281
R3_32 Y:13 Y:25 3.58332
R3_33 Y:13 Y:19 50.1665
R3_34 Y:14 Y:22 21900.0
R3_35 Y:15 Y:16 63.5281
R3_36 Y:15 Y:20 5.9722
R3_37 Y:16 Y:21 5.04281
R3_38 Y:17 Y:18 63.5281
R3_39 Y:17 Y:19 25.0832
R3_40 Y:17 Y:26 3.58332
R3_41 Y:18 Y:24 43800.0

*|NET A 1.61296e-05PF
*|P (A B 0 0.0210 0.0720)
*|I (M10:GATE M10 GATE I 3.6e-19 0.0420 0.1080)
*|I (M5:GATE M5 GATE I 3.6e-19 0.0420 0.0360)
C4_1 A:7 VDD 2.52952e-20
C4_2 A:8 VDD 3.46766e-20
C4_3 A:10 VDD 1.48781e-18
C4_4 A:10 VDD:5 1.1494e-19
C4_5 A:7 VDD:13 1.15459e-19
C4_6 A:8 VDD:18 1.48933e-20
C4_7 A:10 VDD:18 1.18559e-19
C4_8 A:8 VDD:23 1.58034e-18
C4_9 A:10 VDD:23 4.73109e-19
C4_10 A:4 VSS:8 4.59524e-19
C4_11 A:5 VSS:8 7.89427e-21
C4_12 A:10 VSS:17 6.93342e-19
C4_13 A:10 VSS:21 1.41788e-19
Cg4_14 A:4 VSS 1.09775e-19
Cg4_15 A:6 VSS 3.4119e-19
Cg4_16 A:7 VSS 2.29215e-19
Cg4_17 A:8 VSS 1.9849e-19
Cg4_18 A:10 VSS 3.05671e-18
R4_1 A A:10 12.8402
R4_2 A A:13 29.4429
R4_3 A A:9 63.5281
R4_4 M10:GATE A:7 13.1313
R4_5 M10:GATE A:6 7.57576
R4_6 M5:GATE A:5 7.57576
R4_7 M5:GATE A:4 7.57576
R4_8 A:4 A:11 5.55556
R4_9 A:5 A:8 10.6061
R4_10 A:6 A:8 10.6061
R4_11 A:8 A:9 27.7339
R4_12 A:9 A:12 7.92396

*|NET B 1.57375e-05PF
*|P (B B 0 0.0630 0.0720)
*|I (M4:GATE M4 GATE I 3.6e-19 0.0840 0.0360)
*|I (M9:GATE M9 GATE I 3.6e-19 0.0840 0.1080)
C5_1 B:7 VDD 2.52952e-20
C5_2 B:8 VDD 4.20689e-20
C5_3 B:10 VDD 1.58945e-18
C5_4 B:10 VDD:5 8.37832e-20
C5_5 B:7 VDD:13 1.15459e-19
C5_6 B:10 VDD:23 1.08178e-19
C5_7 B:4 VSS:8 4.59524e-19
C5_8 B:5 VSS:8 7.3486e-21
C5_9 B:8 VSS:8 9.81086e-19
C5_10 B:10 VSS:8 4.03869e-19
C5_11 B:8 VSS:17 9.19865e-21
C5_12 B:10 VSS:17 4.06348e-19
C5_13 B:10 VSS:21 1.21881e-19
C5_14 B:10 Y:19 9.61528e-19
C5_15 B:10 Y:20 1.35098e-19
C5_16 B:10 A:10 3.25978e-18
Cg5_17 B:4 VSS 1.09775e-19
Cg5_18 B:6 VSS 3.4119e-19
Cg5_19 B:7 VSS 2.29215e-19
Cg5_20 B:8 VSS 2.14171e-19
Cg5_21 B:10 VSS 1.79511e-18
R5_1 B B:10 12.8402
R5_2 B B:13 29.4429
R5_3 B B:9 63.5281
R5_4 M4:GATE B:5 7.57576
R5_5 M4:GATE B:4 7.57576
R5_6 M9:GATE B:7 13.1313
R5_7 M9:GATE B:6 7.57576
R5_8 B:4 B:11 5.55556
R5_9 B:5 B:8 10.6061
R5_10 B:6 B:8 10.6061
R5_11 B:8 B:9 27.7339
R5_12 B:9 B:12 7.92396

*|NET E 1.742e-05PF
*|P (E B 0 0.1050 0.0720)
*|I (M3:GATE M3 GATE I 3.6e-19 0.1260 0.0360)
*|I (M8:GATE M8 GATE I 3.6e-19 0.1260 0.1080)
C6_1 E:11 VSS:4 1.53602e-20
C6_2 E:4 VSS:8 4.61602e-19
C6_3 E:5 VSS:8 7.89427e-21
C6_4 E:11 VSS:8 3.53609e-20
C6_5 E:11 VSS:17 3.13749e-19
C6_6 E:4 VSS:21 4.00426e-20
C6_7 E:11 VSS:21 1.60133e-19
C6_8 E:4 M2:DRN 1.72218e-20
C6_9 E:9 M9:DRN 1.65859e-20
C6_10 E:6 Y:7 1.83918e-19
C6_11 E:9 Y:7 1.6205e-18
C6_12 E:11 Y:7 1.03961e-19
C6_13 E:6 Y:19 5.62864e-20
C6_14 E:7 Y:19 5.16341e-20
C6_15 E:8 Y:19 1.9335e-20
C6_16 E:9 Y:19 1.24808e-19
C6_17 E:11 Y:19 1.6063e-18
C6_18 E:11 Y:20 2.0331e-19
C6_19 E:11 B:10 1.99578e-18
Cg6_20 E:4 VSS 2.38697e-19
Cg6_21 E:5 VSS 5.97658e-20
Cg6_22 E:6 VSS 3.4119e-19
Cg6_23 E:8 VSS 3.938e-19
Cg6_24 E:9 VSS 1.743e-19
Cg6_25 E:11 VSS 1.36225e-18
R6_1 E E:11 12.8402
R6_2 E E:14 12.8402
R6_3 E E:10 63.5281
R6_4 M3:GATE E:5 7.57576
R6_5 M3:GATE E:4 7.57576
R6_6 M8:GATE E:7 7.57576
R6_7 M8:GATE E:6 7.57576
R6_8 E:4 E:12 5.55556
R6_9 E:5 E:9 10.6061
R6_10 E:6 E:9 10.6061
R6_11 E:7 E:8 5.55556
R6_12 E:9 E:10 27.7339
R6_13 E:10 E:13 7.92396

*|NET C 1.74795e-05PF
*|P (C B 0 0.1470 0.0720)
*|I (M2:GATE M2 GATE I 3.6e-19 0.1680 0.0360)
*|I (M7:GATE M7 GATE I 3.6e-19 0.1680 0.1080)
C7_1 C:8 VDD 5.14487e-20
C7_2 C:11 VDD 1.38275e-19
C7_3 C:6 VDD:13 1.83918e-19
C7_4 C:8 VDD:13 1.15217e-19
C7_5 C:9 VDD:13 1.64035e-18
C7_6 C:11 VDD:13 1.12105e-19
C7_7 C:9 VDD:21 1.44493e-20
C7_8 C:4 VSS:8 4.59524e-19
C7_9 C:5 VSS:8 7.89427e-21
C7_10 C:11 VSS:17 1.98843e-19
C7_11 C:4 VSS:21 2.84649e-20
C7_12 C:11 VSS:21 1.38275e-19
C7_13 C:11 Y:7 3.53609e-20
C7_14 C:11 Y:10 1.53602e-20
C7_15 C:6 Y:19 4.98609e-20
C7_16 C:7 Y:19 5.05415e-20
C7_17 C:8 Y:19 1.9335e-20
C7_18 C:9 Y:19 5.78449e-20
C7_19 C:11 Y:19 1.57513e-18
C7_20 C:5 Y:20 3.77742e-20
C7_21 C:6 Y:20 1.59282e-19
C7_22 C:11 Y:20 2.05551e-18
C7_23 C:4 E:4 5.06651e-19
C7_24 C:11 E:5 2.44421e-20
C7_25 C:11 E:6 1.83969e-19
C7_26 C:11 E:11 1.95465e-18
Cg7_27 C:4 VSS 1.4709e-19
Cg7_28 C:6 VSS 3.4119e-19
Cg7_29 C:8 VSS 2.27134e-19
Cg7_30 C:9 VSS 1.88841e-19
Cg7_31 C:11 VSS 1.36388e-18
R7_1 C C:11 12.8402
R7_2 C C:14 12.8402
R7_3 C C:10 63.5281
R7_4 M2:GATE C:5 7.57576
R7_5 M2:GATE C:4 7.57576
R7_6 M7:GATE C:7 7.57576
R7_7 M7:GATE C:6 7.57576
R7_8 C:4 C:12 5.55556
R7_9 C:5 C:9 10.6061
R7_10 C:6 C:9 10.6061
R7_11 C:7 C:8 5.55556
R7_12 C:9 C:10 27.7339
R7_13 C:10 C:13 7.92396

*|NET D 1.73578e-05PF
*|P (D B 0 0.2310 0.0720)
*|I (M1:GATE M1 GATE I 3.6e-19 0.2100 0.0360)
*|I (M6:GATE M6 GATE I 3.6e-19 0.2100 0.1080)
C8_1 D:4 VSS:8 4.59524e-19
C8_2 D:5 VSS:8 7.89427e-21
C8_3 D:11 VSS:17 2.31439e-19
C8_4 D:11 VSS:20 3.09564e-20
C8_5 D:4 VSS:21 5.33664e-20
C8_6 D:11 VSS:21 1.54669e-19
C8_7 D:9 M6:DRN 1.45522e-20
C8_8 D:11 M6:DRN 7.01306e-22
C8_9 D:4 Y:8 1.82222e-19
C8_10 D:5 Y:8 6.87286e-19
C8_11 D:6 Y:8 4.65014e-19
C8_12 D:11 Y:8 6.67928e-20
C8_13 D:9 Y:9 1.63028e-18
C8_14 D:11 Y:9 1.13363e-19
C8_15 D:5 Y:11 1.22524e-18
C8_16 D:11 Y:11 1.53602e-20
C8_17 D:11 Y:12 4.85918e-21
C8_18 D:6 Y:19 1.1044e-19
C8_19 D:7 Y:19 4.39739e-20
C8_20 D:8 Y:19 3.14075e-20
C8_21 D:9 Y:19 5.95675e-20
C8_22 D:11 Y:19 1.60552e-18
C8_23 D:5 Y:20 3.77742e-20
C8_24 D:6 Y:20 1.59282e-19
C8_25 D:7 Y:20 1.23036e-19
C8_26 D:11 Y:20 2.11447e-18
Cg8_27 D:4 VSS 1.47564e-19
Cg8_28 D:6 VSS 9.8281e-19
Cg8_29 D:8 VSS 4.48986e-19
Cg8_30 D:9 VSS 5.76142e-19
Cg8_31 D:11 VSS 1.89193e-18
R8_1 D D:11 12.8402
R8_2 D D:14 12.8402
R8_3 D D:10 63.5281
R8_4 M1:GATE D:5 7.57576
R8_5 M1:GATE D:4 7.57576
R8_6 M6:GATE D:7 7.57576
R8_7 M6:GATE D:6 7.57576
R8_8 D:4 D:12 5.55556
R8_9 D:5 D:9 10.6061
R8_10 D:6 D:9 10.6061
R8_11 D:7 D:8 5.55556
R8_12 D:9 D:10 27.7339
R8_13 D:10 D:13 7.92396

*|NET 14 6.31019e-07PF
*|I (M10:DRN M10 DRN B 0 0.0480 0.1080)
*|I (M9:SRC M9 SRC B 0 0.0780 0.1080)
C10_1 M10:DRN VDD 1.13085e-19
C10_2 M10:DRN VDD:5 2.82443e-20
C10_3 M10:DRN VDD:23 2.13821e-20
C10_4 M10:DRN VSS:8 4.14942e-20
C10_5 M10:DRN B:8 3.20941e-19
C10_6 M10:DRN B:10 1.05872e-19
R10_1 M10:DRN M9:SRC 15000.0

*|NET 15 5.71697e-07PF
*|I (M6:SRC M6 SRC B 0 0.2040 0.1080)
*|I (M7:DRN M7 DRN B 0 0.1740 0.1080)
C11_1 M7:DRN VDD 1.09583e-19
C11_2 M7:DRN VDD:6 3.01108e-20
C11_3 M7:DRN VDD:13 2.48114e-20
C11_4 M7:DRN Y:8 1.93034e-19
C11_5 M7:DRN Y:19 9.47917e-20
C11_6 M7:DRN Y:20 1.19367e-19
R11_1 M6:SRC M7:DRN 15000.0

*|NET 4 3.15667e-05PF
*|I (M3:SRC M3 SRC B 0 0.1200 0.0360)
*|I (M4:DRN M4 DRN B 0 0.0900 0.0360)
*|I (M5:SRC M5 SRC B 0 0.0360 0.0360)
C12_1 M4:DRN VSS:4 3.00786e-20
C12_2 4:12 VSS:4 2.10898e-19
C12_3 M4:DRN VSS:8 4.56638e-20
C12_4 M5:SRC VSS:8 3.48249e-21
C12_5 4:4 VSS:8 1.93254e-18
C12_6 4:5 VSS:8 2.32373e-18
C12_7 4:6 VSS:8 5.50499e-20
C12_8 4:12 VSS:8 7.91797e-19
C12_9 4:4 VSS:17 1.06597e-18
C12_10 4:5 VSS:17 5.7019e-21
C12_11 4:6 VSS:17 8.02001e-19
C12_12 4:12 VSS:17 5.85991e-19
C12_13 4:4 VSS:18 2.47523e-20
C12_14 4:6 VSS:18 3.00786e-20
C12_15 4:12 VSS:18 4.26629e-20
C12_16 4:5 VSS:19 1.82889e-19
C12_17 4:4 VSS:21 1.52653e-19
C12_18 4:5 VSS:21 1.00099e-19
C12_19 4:12 VSS:21 6.98627e-18
C12_20 4:12 A:4 2.82147e-20
C12_21 4:12 A:5 5.16541e-20
C12_22 4:12 A:6 5.11439e-20
C12_23 4:4 A:8 9.60898e-19
C12_24 M5:SRC A:10 1.04827e-20
C12_25 4:4 A:10 4.10464e-19
C12_26 4:6 A:10 2.03074e-21
C12_27 4:12 A:10 1.70066e-18
C12_28 4:12 B:4 3.20004e-20
C12_29 4:12 B:5 6.49795e-20
C12_30 4:12 B:6 7.39175e-20
C12_31 4:4 B:10 3.53609e-20
C12_32 4:6 B:10 1.53602e-20
C12_33 4:12 B:10 1.69395e-18
C12_34 4:5 E:5 6.92453e-19
C12_35 4:7 E:5 1.24663e-18
C12_36 4:12 E:5 5.92202e-20
C12_37 4:5 E:6 1.83918e-19
C12_38 4:5 E:9 9.60833e-19
C12_39 4:5 E:11 3.89081e-19
C12_40 4:12 E:11 1.61432e-18
Cg12_41 4:4 VSS 6.25951e-19
Cg12_42 4:5 VSS 5.17556e-19
Cg12_43 4:6 VSS 2.55731e-19
Cg12_44 4:7 VSS 2.79528e-19
Cg12_45 4:12 VSS 2.31925e-18
R12_1 M3:SRC 4:7 30000.0
R12_2 M3:SRC 4:14 20270.3
R12_3 M3:SRC 4:5 57692.3
R12_4 M3:SRC 4:11 30000.0
R12_5 M4:DRN 4:7 30000.0
R12_6 M4:DRN 4:14 20270.3
R12_7 M4:DRN 4:5 57692.3
R12_8 M4:DRN 4:11 30000.0
R12_9 M5:SRC 4:6 30000.0
R12_10 M5:SRC 4:13 20270.3
R12_11 M5:SRC 4:4 57692.3
R12_12 M5:SRC 4:9 30000.0
R12_13 4:4 4:9 5.51688
R12_14 4:5 4:11 5.51634
R12_15 4:6 4:9 14.0605
R12_16 4:6 4:13 98999.9
R12_17 4:7 4:11 14.0605
R12_18 4:7 4:14 49500.0
R12_19 4:8 4:9 63.5281
R12_20 4:8 4:12 3.58332
R12_21 4:8 4:10 50.1665
R12_22 4:9 4:13 3.76373
R12_23 4:10 4:11 63.5281
R12_24 4:10 4:15 3.58332
R12_25 4:11 4:14 3.7634

*|NET 6 2.95973e-05PF
*|I (M1:DRN M1 DRN B 0 0.2160 0.0360)
*|I (M2:SRC M2 SRC B 0 0.1620 0.0360)
*|I (M3:DRN M3 DRN B 0 0.1320 0.0360)
C13_1 M1:DRN VSS:8 1.74124e-20
C13_2 M3:DRN VSS:8 2.09115e-20
C13_3 6:4 VSS:8 2.32373e-18
C13_4 6:5 VSS:8 2.32373e-18
C13_5 6:12 VSS:8 3.25041e-19
C13_6 6:4 VSS:17 5.7019e-21
C13_7 6:12 VSS:17 2.581e-19
C13_8 6:12 VSS:19 1.83263e-19
C13_9 6:12 VSS:20 1.23825e-19
C13_10 6:4 VSS:21 1.21348e-19
C13_11 6:5 VSS:21 1.12768e-19
C13_12 6:12 VSS:21 6.9309e-18
C13_13 6:4 M2:DRN 3.04542e-20
C13_14 6:6 M2:DRN 3.00786e-20
C13_15 6:12 M2:DRN 4.89719e-20
C13_16 6:5 M6:DRN 3.52036e-21
C13_17 M1:DRN Y:8 3.58078e-20
C13_18 6:12 Y:8 3.85234e-19
C13_19 6:5 Y:9 1.21861e-19
C13_20 M1:DRN Y:11 2.91132e-20
C13_21 6:12 Y:11 2.0725e-19
C13_22 6:12 Y:19 9.81773e-19
C13_23 6:4 Y:20 5.75251e-20
C13_24 6:6 Y:20 3.30734e-20
C13_25 6:12 Y:20 1.79973e-18
C13_26 6:4 C:4 1.82222e-19
C13_27 6:4 C:5 6.86854e-19
C13_28 6:6 C:5 1.2292e-18
C13_29 6:12 C:5 6.85477e-20
C13_30 6:4 C:6 1.83918e-19
C13_31 6:12 C:6 1.1048e-19
C13_32 6:4 C:9 9.60833e-19
C13_33 6:4 C:11 3.88867e-19
C13_34 6:12 C:11 1.58599e-18
C13_35 6:12 D:5 4.3415e-20
C13_36 6:12 D:6 1.1048e-19
C13_37 6:5 D:9 8.30991e-19
C13_38 M1:DRN D:11 7.01306e-22
C13_39 6:5 D:11 3.75132e-19
C13_40 6:7 D:11 4.85918e-21
C13_41 6:12 D:11 1.61432e-18
C13_42 M3:DRN 4:5 3.04542e-20
C13_43 6:12 4:5 6.58839e-20
C13_44 M3:DRN 4:7 3.00786e-20
C13_45 6:12 4:7 6.05689e-20
C13_46 6:12 4:12 1.2241e-18
Cg13_47 6:4 VSS 4.75627e-19
Cg13_48 6:5 VSS 3.02077e-19
Cg13_49 6:6 VSS 2.432e-19
Cg13_50 6:7 VSS 1.78742e-19
Cg13_51 6:12 VSS 1.71666e-18
R13_1 M1:DRN 6:7 30000.0
R13_2 M1:DRN 6:14 20270.3
R13_3 M1:DRN 6:5 57692.3
R13_4 M1:DRN 6:11 30000.0
R13_5 M2:SRC 6:6 30000.0
R13_6 M2:SRC 6:13 20270.3
R13_7 M2:SRC 6:4 57692.3
R13_8 M2:SRC 6:9 30000.0
R13_9 M3:DRN 6:6 30000.0
R13_10 M3:DRN 6:13 20270.3
R13_11 M3:DRN 6:4 57692.3
R13_12 M3:DRN 6:9 30000.0
R13_13 6:4 6:9 5.51634
R13_14 6:5 6:11 5.51688
R13_15 6:6 6:9 14.0605
R13_16 6:6 6:13 49500.0
R13_17 6:7 6:11 14.0605
R13_18 6:7 6:14 98999.9
R13_19 6:8 6:9 63.5281
R13_20 6:8 6:12 3.58332
R13_21 6:8 6:10 50.1665
R13_22 6:9 6:13 3.7634
R13_23 6:10 6:11 63.5281
R13_24 6:10 6:15 3.58332
R13_25 6:11 6:14 3.76373

*|NET _generated_16 2.86e-06PF
C14_1 _generated_16:1 VSS:17 6.59895e-19
C14_2 _generated_16:1 VSS:21 2.25577e-20
C14_3 _generated_16:1 A:10 1.35335e-19
C14_4 _generated_16:1 4:4 3.44446e-19
C14_5 _generated_16:1 4:12 1.63302e-19
Cg14_6 _generated_16:1 VSS 9.5542e-19
R14_1 _generated_16:1 _generated_16:2 28.2828

*|NET _generated_17 3.08088e-06PF
C15_1 _generated_17:1 VDD 4.89892e-20
C15_2 _generated_17:1 VDD:13 1.18927e-19
C15_3 _generated_17:1 VDD:23 3.74453e-19
C15_4 _generated_17:1 VSS:8 1.47021e-19
C15_5 _generated_17:1 VSS:17 5.65589e-19
C15_6 _generated_17:1 A:10 3.15962e-19
C15_7 _generated_17:1 _generated_16:1 5.79044e-19
Cg15_8 _generated_17:1 VSS 9.3089e-19
R15_1 _generated_17:1 _generated_17:2 28.2828

*|NET _generated_18 5.33996e-06PF
C16_1 _generated_18:1 VSS:8 4.61748e-19
C16_2 _generated_18:1 VSS:17 2.98844e-20
C16_3 _generated_18:1 VSS:21 9.68154e-20
C16_4 _generated_18:1 D:4 4.75026e-20
C16_5 _generated_18:1 D:6 2.39886e-19
C16_6 _generated_18:1 D:11 6.69052e-20
C16_7 _generated_18:1 6:5 3.81915e-19
Cg16_8 _generated_18:1 VSS 3.41115e-18
R16_1 _generated_18:1 _generated_18:2 28.2828

*|NET _generated_19 4.96695e-06PF
C17_1 _generated_19:1 VDD 1.91825e-19
C17_2 _generated_19:1 VDD:13 1.19386e-19
C17_3 _generated_19:1 Y:9 3.81915e-19
C17_4 _generated_19:1 D:6 2.39886e-19
C17_5 _generated_19:1 D:8 4.75026e-20
C17_6 _generated_19:1 D:11 5.98215e-20
C17_7 _generated_19:1 _generated_18:1 6.0415e-19
Cg17_8 _generated_19:1 VSS 3.32246e-18
R17_1 _generated_19:1 _generated_19:2 28.2828

*
* Instance Section
*
MM1 M1:DRN M1:GATE M1:SRC VSS NMOS_LVT l=0.012u w=0.03u NF=1
MM10 M10:DRN M10:GATE M10:SRC VDD PMOS_LVT l=0.012u w=0.03u NF=1
MM2 M2:DRN M2:GATE M2:SRC VSS NMOS_LVT l=0.012u w=0.03u NF=1
MM3 M3:DRN M3:GATE M3:SRC VSS NMOS_LVT l=0.012u w=0.03u NF=1
MM4 M4:DRN M4:GATE M4:SRC VSS NMOS_LVT l=0.012u w=0.03u NF=1
MM5 M5:DRN M5:GATE M5:SRC VSS NMOS_LVT l=0.012u w=0.03u NF=1
MM6 M6:DRN M6:GATE M6:SRC VDD PMOS_LVT l=0.012u w=0.03u NF=1
MM7 M7:DRN M7:GATE M7:SRC VDD PMOS_LVT l=0.012u w=0.03u NF=1
MM8 M8:DRN M8:GATE M8:SRC VDD PMOS_LVT l=0.012u w=0.03u NF=1
MM9 M9:DRN M9:GATE M9:SRC VDD PMOS_LVT l=0.012u w=0.03u NF=1

.ENDS
