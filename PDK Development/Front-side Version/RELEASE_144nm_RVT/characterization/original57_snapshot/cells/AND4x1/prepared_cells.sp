*
*|DSPF 1.3
*|DESIGN AND4x1
*|DATE "Tue Nov  3 20:50:57 2026"
*|VENDOR "Synopsys"
*|PROGRAM "StarRC"
*|VERSION "X-2025.06-SP1"
*|DIVIDER /
*|DELIMITER :
**FORMAT SPF
*

** COMMENTS

** OPERATING_TEMPERATURE 25
** GLOBAL_TEMPERATURE 25
**
** TCAD_GRD_FILE /cedar/cedar_coe/ece-limsk/yhuang861/GRO/.planning/experiments_migrated_20261022/usc144_github_release_20261103/sources/github_FSPR.nxtgrd
**   TCAD_TIME_STAMP Tue Mar 31 05:07:55 2026
**   TCADGRD_VERSION 89

.SUBCKT AND4x1 VSS VDD Y A B C D

*|GROUND_NET VSS

*|NET VSS 0.000103399PF
*|P (VSS B 0 0.1470 0.0000)
*|I (M1:SRC M1 SRC B 0 0.2460 0.0360)
*|I (M5:SRC M5 SRC B 0 0.0360 0.0360)
Cg1_1 VSS:4 VSS 2.52098e-19
Cg1_2 VSS:5 VSS 1.90317e-19
Cg1_3 VSS:15 VSS 3.01322e-18
Cg1_4 VSS:18 VSS 3.92121e-17
Cg1_5 VSS:21 VSS 4.43154e-18
Cg1_6 VSS:23 VSS 8.65579e-18
Cg1_7 VSS:24 VSS 5.23865e-19
R1_1 VSS VSS:9 25.0832
R1_2 VSS VSS:12 25.0832
R1_3 VSS VSS:11 63.5281
R1_4 M1:SRC VSS:20 30000.0
R1_5 M1:SRC VSS:5 30000.0
R1_6 M1:SRC VSS:29 15000.0
R1_7 M5:SRC VSS:19 30000.0
R1_8 M5:SRC VSS:4 30000.0
R1_9 M5:SRC VSS:27 15000.0
R1_10 VSS:4 VSS:27 7.8411
R1_11 VSS:4 VSS:24 12.4587
R1_12 VSS:5 VSS:29 7.8411
R1_13 VSS:5 VSS:15 12.4587
R1_14 VSS:6 VSS:23 17.9166
R1_15 VSS:6 VSS:7 25.0832
R1_16 VSS:6 VSS:24 31.764
R1_17 VSS:7 VSS:8 63.5281
R1_18 VSS:7 VSS:9 25.0832
R1_19 VSS:8 VSS:24 50.1851
R1_20 VSS:8 VSS:10 55.4677
R1_21 VSS:9 VSS:10 63.5281
R1_22 VSS:10 VSS:11 55.4677
R1_23 VSS:11 VSS:13 55.4677
R1_24 VSS:12 VSS:13 63.5281
R1_25 VSS:12 VSS:14 25.0832
R1_26 VSS:13 VSS:15 50.1851
R1_27 VSS:14 VSS:15 31.764
R1_28 VSS:14 VSS:16 25.0832
R1_29 VSS:15 VSS:17 50.1851
R1_30 VSS:16 VSS:17 63.5281
R1_31 VSS:16 VSS:31 17.9166
R1_32 VSS:17 VSS:26 39.6198
R1_33 VSS:18 VSS:21 7778.54
R1_34 VSS:19 VSS:27 7.8411
R1_35 VSS:19 VSS:28 1.77981
R1_36 VSS:20 VSS:29 7.8411
R1_37 VSS:20 VSS:30 1.77981
R1_38 VSS:21 VSS:22 2149.39
R1_39 VSS:24 VSS:25 34.3372
R1_40 VSS:24 VSS:18 0.01

*|NET VDD 6.69728e-05PF
*|P (VDD B 0 0.1470 0.1440)
*|I (M10:SRC M10 SRC B 0 0.0360 0.1080)
*|I (M6:SRC M6 SRC B 0 0.2460 0.1080)
*|I (M7:DRN M7 DRN B 0 0.1740 0.1080)
*|I (M8:SRC M8 SRC B 0 0.1200 0.1080)
*|I (M9:DRN M9 DRN B 0 0.0900 0.1080)
C2_1 VDD VSS:15 7.79004e-20
C2_2 VDD:18 VSS:15 1.66467e-19
C2_3 VDD:21 VSS:15 6.70874e-21
C2_4 VDD:25 VSS:15 4.01983e-21
C2_5 VDD:28 VSS:15 6.38861e-20
C2_6 VDD VSS:18 1.58065e-18
C2_7 VDD:7 VSS:18 8.02899e-19
C2_8 VDD:8 VSS:18 8.02037e-19
C2_9 VDD:18 VSS:18 3.57222e-19
C2_10 VDD:27 VSS:18 1.49745e-18
C2_11 VDD:28 VSS:18 1.49995e-18
C2_12 VDD VSS:23 1.15672e-18
C2_13 VDD:18 VSS:23 2.76282e-20
C2_14 VDD VSS:24 4.39458e-22
C2_15 VDD:21 VSS:24 1.93143e-21
C2_16 VDD:28 VSS:24 8.73266e-20
Cg2_17 VDD VSS 9.05471e-18
Cg2_18 VDD:7 VSS 2.76091e-19
Cg2_19 VDD:8 VSS 2.80944e-19
Cg2_20 VDD:9 VSS 1.78742e-19
Cg2_21 VDD:10 VSS 1.90317e-19
Cg2_22 VDD:18 VSS 1.51533e-17
Cg2_23 VDD:21 VSS 5.43919e-21
Cg2_24 VDD:24 VSS 5.43766e-21
Cg2_25 VDD:25 VSS 5.43766e-21
Cg2_26 VDD:26 VSS 6.17039e-19
Cg2_27 VDD:27 VSS 8.35038e-19
Cg2_28 VDD:28 VSS 8.29438e-19
R2_1 VDD VDD:14 25.0832
R2_2 VDD VDD:15 63.5281
R2_3 VDD VDD:16 25.0832
R2_4 VDD VDD:22 45366.3
R2_5 M10:SRC VDD:21 30000.0
R2_6 M10:SRC VDD:7 30000.0
R2_7 M10:SRC VDD:31 15000.0
R2_8 M6:SRC VDD:25 30000.0
R2_9 M6:SRC VDD:10 30000.0
R2_10 M6:SRC VDD:37 15000.0
R2_11 M7:DRN VDD:24 30000.0
R2_12 M7:DRN VDD:9 30000.0
R2_13 M7:DRN VDD:35 15000.0
R2_14 M8:SRC VDD:23 30000.0
R2_15 M8:SRC VDD:8 30000.0
R2_16 M8:SRC VDD:33 15000.0
R2_17 M9:DRN VDD:23 30000.0
R2_18 M9:DRN VDD:8 30000.0
R2_19 M9:DRN VDD:33 15000.0
R2_20 VDD:7 VDD:31 7.8411
R2_21 VDD:7 VDD:32 1.77981
R2_22 VDD:8 VDD:33 7.84041
R2_23 VDD:8 VDD:34 1.77981
R2_24 VDD:9 VDD:35 7.8411
R2_25 VDD:9 VDD:36 1.77981
R2_26 VDD:10 VDD:37 7.8411
R2_27 VDD:10 VDD:38 1.77981
R2_28 VDD:11 VDD:39 17.9166
R2_29 VDD:11 VDD:12 25.0832
R2_30 VDD:11 VDD:28 31.764
R2_31 VDD:12 VDD:13 63.5281
R2_32 VDD:12 VDD:14 25.0832
R2_33 VDD:13 VDD:28 50.1851
R2_34 VDD:13 VDD:27 50.1851
R2_35 VDD:14 VDD:27 31.764
R2_36 VDD:15 VDD:27 50.1851
R2_37 VDD:15 VDD:26 50.1851
R2_38 VDD:16 VDD:17 25.0832
R2_39 VDD:16 VDD:26 31.764
R2_40 VDD:17 VDD:18 31.764
R2_41 VDD:17 VDD:19 25.0832
R2_42 VDD:18 VDD:20 50.1851
R2_43 VDD:18 VDD:25 12.4587
R2_44 VDD:18 VDD:26 44.9024
R2_45 VDD:19 VDD:20 63.5281
R2_46 VDD:19 VDD:40 17.9166
R2_47 VDD:20 VDD:30 39.6198
R2_48 VDD:21 VDD:31 7.8411
R2_49 VDD:21 VDD:28 12.4587
R2_50 VDD:23 VDD:33 7.84041
R2_51 VDD:23 VDD:27 12.4587
R2_52 VDD:24 VDD:35 7.8411
R2_53 VDD:24 VDD:26 12.4587
R2_54 VDD:25 VDD:37 7.8411
R2_55 VDD:28 VDD:29 34.3372

*|NET Y 1.73369e-05PF
*|P (Y B 0 0.2730 0.0720)
*|I (M1:DRN M1 DRN B 0 0.2580 0.0360)
*|I (M6:DRN M6 DRN B 0 0.2580 0.1080)
C3_1 M1:DRN VSS:5 3.78986e-20
C3_2 Y:12 VSS:5 1.77132e-19
C3_3 M1:DRN VSS:15 5.55438e-20
C3_4 Y:4 VSS:15 2.32339e-18
C3_5 Y:12 VSS:15 1.86634e-19
C3_6 Y:12 VSS:18 5.90726e-19
C3_7 Y:12 VSS:21 7.77805e-20
C3_8 Y:12 VSS:22 1.93229e-19
C3_9 Y:4 VSS:23 1.61456e-19
C3_10 Y:12 VSS:23 1.43597e-18
C3_11 Y:5 VDD 1.93704e-19
C3_12 Y:12 VDD 1.55482e-18
C3_13 M6:DRN VDD:10 3.78986e-20
C3_14 Y:12 VDD:10 1.77132e-19
C3_15 M6:DRN VDD:18 6.2592e-20
C3_16 Y:5 VDD:18 1.05946e-18
C3_17 Y:12 VDD:18 3.05127e-19
Cg3_18 Y:4 VSS 3.15906e-19
Cg3_19 Y:5 VSS 2.8933e-19
Cg3_20 Y:6 VSS 1.78742e-19
Cg3_21 Y:7 VSS 1.78742e-19
Cg3_22 Y:12 VSS 3.31637e-18
R3_1 Y Y:10 21.4999
R3_2 Y Y:8 21.4999
R3_3 M1:DRN Y:6 30000.0
R3_4 M1:DRN Y:4 30000.0
R3_5 M1:DRN Y:9 15000.0
R3_6 M6:DRN Y:7 30000.0
R3_7 M6:DRN Y:5 30000.0
R3_8 M6:DRN Y:11 15000.0
R3_9 Y:4 Y:9 9.78801
R3_10 Y:5 Y:11 9.78801
R3_11 Y:6 Y:9 9.78801
R3_12 Y:7 Y:11 9.78801
R3_13 Y:8 Y:9 63.5281
R3_14 Y:8 Y:12 7.8833
R3_15 Y:10 Y:11 63.5281
R3_16 Y:10 Y:13 7.94303

*|NET A 1.85936e-05PF
*|P (A B 0 0.0210 0.0720)
*|I (M10:GATE M10 GATE I 3.6e-19 0.0420 0.1080)
*|I (M5:GATE M5 GATE I 3.6e-19 0.0420 0.0360)
C4_1 A:10 VSS:4 2.33814e-19
C4_2 A:4 VSS:15 4.61602e-19
C4_3 A:5 VSS:15 7.89427e-21
C4_4 A:10 VSS:15 9.63817e-20
C4_5 A:10 VSS:18 9.44842e-19
C4_6 A:10 VSS:19 4.85975e-20
C4_7 A:4 VSS:23 2.75992e-20
C4_8 A:10 VSS:23 1.47874e-18
C4_9 A:8 VSS:24 1.01516e-18
C4_10 A:10 VSS:24 5.96082e-19
C4_11 A:4 VDD 4.02543e-21
C4_12 A:7 VDD 4.85422e-20
C4_13 A:8 VDD 2.83023e-20
C4_14 A:10 VDD 1.48658e-18
C4_15 A:10 VDD:7 1.1494e-19
C4_16 A:7 VDD:18 1.15802e-19
C4_17 A:8 VDD:21 1.6302e-20
C4_18 A:10 VDD:21 1.18973e-19
C4_19 A:8 VDD:28 1.72892e-18
C4_20 A:10 VDD:28 4.73109e-19
Cg4_21 A:4 VSS 1.09486e-19
Cg4_22 A:6 VSS 3.4119e-19
Cg4_23 A:7 VSS 2.31874e-19
Cg4_24 A:8 VSS 2.09702e-19
Cg4_25 A:10 VSS 3.74095e-18
R4_1 A A:10 29.3832
R4_2 A A:13 29.4429
R4_3 A A:9 63.5281
R4_4 M10:GATE A:7 13.1313
R4_5 M10:GATE A:6 7.57576
R4_6 M5:GATE A:5 7.57576
R4_7 M5:GATE A:4 7.57576
R4_8 A:4 A:11 5.55556
R4_9 A:5 A:8 10.6061
R4_10 A:6 A:8 10.6061
R4_11 A:8 A:9 27.7339
R4_12 A:9 A:12 10.5653

*|NET B 1.61433e-05PF
*|P (B B 0 0.0630 0.0720)
*|I (M4:GATE M4 GATE I 3.6e-19 0.0840 0.0360)
*|I (M9:GATE M9 GATE I 3.6e-19 0.0840 0.1080)
C5_1 B:11 VSS:4 8.37832e-20
C5_2 B:4 VSS:15 4.61602e-19
C5_3 B:5 VSS:15 7.89427e-21
C5_4 B:11 VSS:15 8.83916e-20
C5_5 B:11 VSS:18 4.01701e-19
C5_6 B:11 VSS:23 1.57773e-18
C5_7 B:11 VSS:24 1.07916e-19
C5_8 B:11 A:10 3.2141e-18
Cg5_9 B:4 VSS 1.09232e-19
Cg5_10 B:6 VSS 3.4119e-19
Cg5_11 B:8 VSS 3.84125e-19
Cg5_12 B:9 VSS 1.92213e-19
Cg5_13 B:11 VSS 2.20882e-18
R5_1 B B:11 29.3832
R5_2 B B:14 12.8402
R5_3 B B:10 63.5281
R5_4 M4:GATE B:5 7.57576
R5_5 M4:GATE B:4 7.57576
R5_6 M9:GATE B:7 7.57576
R5_7 M9:GATE B:6 7.57576
R5_8 B:4 B:12 5.55556
R5_9 B:5 B:9 10.6061
R5_10 B:6 B:9 10.6061
R5_11 B:7 B:8 5.55556
R5_12 B:9 B:10 27.7339
R5_13 B:10 B:13 7.92396

*|NET C 1.6233e-05PF
*|P (C B 0 0.1050 0.0720)
*|I (M3:GATE M3 GATE I 3.6e-19 0.1260 0.0360)
*|I (M8:GATE M8 GATE I 3.6e-19 0.1260 0.1080)
C6_1 C:4 VSS:15 4.61602e-19
C6_2 C:5 VSS:15 7.89427e-21
C6_3 C:11 VSS:15 8.83916e-20
C6_4 C:11 VSS:18 4.01701e-19
C6_5 C:11 VSS:23 1.65338e-18
C6_6 C:8 VDD 4.17741e-20
C6_7 C:11 VDD 1.47643e-19
C6_8 C:8 VDD:18 1.15217e-19
C6_9 C:9 VDD:23 1.71158e-20
C6_10 C:9 VDD:27 1.62973e-18
C6_11 C:11 VDD:27 1.12105e-19
C6_12 C:11 B:11 3.15556e-18
Cg6_13 C:4 VSS 1.09232e-19
Cg6_14 C:6 VSS 3.4119e-19
Cg6_15 C:8 VSS 2.27134e-19
Cg6_16 C:9 VSS 1.63308e-19
Cg6_17 C:11 VSS 2.01301e-18
R6_1 C C:11 29.3832
R6_2 C C:14 12.8402
R6_3 C C:10 63.5281
R6_4 M3:GATE C:5 7.57576
R6_5 M3:GATE C:4 7.57576
R6_6 M8:GATE C:7 7.57576
R6_7 M8:GATE C:6 7.57576
R6_8 C:4 C:12 5.55556
R6_9 C:5 C:9 10.6061
R6_10 C:6 C:9 10.6061
R6_11 C:7 C:8 5.55556
R6_12 C:9 C:10 27.7339
R6_13 C:10 C:13 7.92396

*|NET D 1.70873e-05PF
*|P (D B 0 0.1470 0.0720)
*|I (M2:GATE M2 GATE I 3.6e-19 0.1680 0.0360)
*|I (M7:GATE M7 GATE I 3.6e-19 0.1680 0.1080)
C7_1 D:4 VSS:15 4.76741e-19
C7_2 D:5 VSS:15 7.89427e-21
C7_3 D:11 VSS:15 8.83916e-20
C7_4 D:11 VSS:18 3.45371e-19
C7_5 D:4 VSS:23 7.99814e-20
C7_6 D:11 VSS:23 1.58371e-18
C7_7 D:11 C:11 3.15556e-18
Cg7_8 D:4 VSS 2.2589e-19
Cg7_9 D:6 VSS 3.4119e-19
Cg7_10 D:8 VSS 4.21372e-19
Cg7_11 D:9 VSS 1.743e-19
Cg7_12 D:11 VSS 2.08138e-18
R7_1 D D:11 29.3832
R7_2 D D:14 12.8402
R7_3 D D:10 63.5281
R7_4 M2:GATE D:5 7.57576
R7_5 M2:GATE D:4 7.57576
R7_6 M7:GATE D:7 7.57576
R7_7 M7:GATE D:6 7.57576
R7_8 D:4 D:12 5.55556
R7_9 D:5 D:9 10.6061
R7_10 D:6 D:9 10.6061
R7_11 D:7 D:8 5.55556
R7_12 D:9 D:10 27.7339
R7_13 D:10 D:13 7.92396

*|NET 12 7.51526e-07PF
*|I (M4:SRC M4 SRC B 0 0.0780 0.0360)
*|I (M5:DRN M5 DRN B 0 0.0480 0.0360)
C9_1 M5:DRN VSS:4 2.82443e-20
C9_2 M5:DRN VSS:15 4.65606e-19
C9_3 M5:DRN VSS:23 1.29997e-19
C9_4 M5:DRN VSS:24 2.13821e-20
C9_5 M5:DRN B:11 1.06296e-19
R9_1 M4:SRC M5:DRN 15000.0

*|NET 13 6.48831e-07PF
*|I (M3:SRC M3 SRC B 0 0.1200 0.0360)
*|I (M4:DRN M4 DRN B 0 0.0900 0.0360)
C10_1 M4:DRN VSS:15 4.65606e-19
C10_2 M4:DRN VSS:23 7.69284e-20
C10_3 M4:DRN C:11 1.06296e-19
R10_1 M3:SRC M4:DRN 15000.0

*|NET 14 7.28864e-07PF
*|I (M2:SRC M2 SRC B 0 0.1620 0.0360)
*|I (M3:DRN M3 DRN B 0 0.1320 0.0360)
C11_1 M3:DRN VSS:15 4.65606e-19
C11_2 M3:DRN VSS:23 1.12203e-19
C11_3 M3:DRN D:11 1.51055e-19
R11_1 M2:SRC M3:DRN 15000.0

*|NET 4 6.24299e-05PF
*|I (M1:GATE M1 GATE I 3.6e-19 0.2520 0.0360)
*|I (M10:DRN M10 DRN B 0 0.0480 0.1080)
*|I (M2:DRN M2 DRN B 0 0.1740 0.0360)
*|I (M6:GATE M6 GATE I 3.6e-19 0.2520 0.1080)
*|I (M7:SRC M7 SRC B 0 0.1620 0.1080)
*|I (M8:DRN M8 DRN B 0 0.1320 0.1080)
*|I (M9:SRC M9 SRC B 0 0.0780 0.1080)
C12_1 4:9 VSS:5 1.25618e-18
C12_2 M2:DRN VSS:15 1.73349e-20
C12_3 4:8 VSS:15 7.19388e-19
C12_4 4:9 VSS:15 7.08412e-19
C12_5 4:10 VSS:15 1.86805e-19
C12_6 4:15 VSS:15 2.60151e-18
C12_7 4:16 VSS:15 9.91502e-19
C12_8 4:29 VSS:15 6.5361e-20
C12_9 4:30 VSS:15 5.46724e-19
C12_10 4:13 VSS:18 1.06604e-18
C12_11 4:14 VSS:18 8.7908e-19
C12_12 4:17 VSS:18 8.02037e-19
C12_13 4:18 VSS:18 8.00234e-19
C12_14 4:28 VSS:18 6.44486e-19
C12_15 4:29 VSS:18 3.81596e-19
C12_16 4:30 VSS:18 2.8622e-19
C12_17 4:29 VSS:21 6.75265e-20
C12_18 4:8 VSS:23 8.50987e-20
C12_19 4:15 VSS:23 1.0248e-19
C12_20 4:28 VSS:23 8.71964e-19
C12_21 4:29 VSS:23 1.22321e-18
C12_22 4:30 VSS:23 9.68666e-19
C12_23 4:12 VDD 1.32299e-19
C12_24 4:13 VDD 2.9288e-19
C12_25 4:14 VDD 2.61668e-19
C12_26 4:16 VDD 4.09483e-20
C12_27 4:28 VDD 9.67629e-18
C12_28 4:29 VDD 9.24449e-20
C12_29 4:30 VDD 8.5529e-19
C12_30 M10:DRN VDD:7 2.82443e-20
C12_31 4:28 VDD:7 6.02467e-20
C12_32 M8:DRN VDD:8 3.01108e-20
C12_33 4:28 VDD:8 1.781e-19
C12_34 4:28 VDD:9 1.32155e-19
C12_35 4:29 VDD:9 1.56602e-19
C12_36 4:11 VDD:10 1.25618e-18
C12_37 4:10 VDD:18 1.83539e-19
C12_38 4:11 VDD:18 6.88271e-19
C12_39 4:12 VDD:18 3.72488e-19
C12_40 4:13 VDD:18 1.19561e-18
C12_41 4:14 VDD:18 1.19561e-18
C12_42 4:16 VDD:18 1.65907e-18
C12_43 4:30 VDD:18 1.9765e-19
C12_44 4:13 VDD:23 2.48114e-20
C12_45 4:17 VDD:23 3.01108e-20
C12_46 4:28 VDD:23 5.44158e-20
C12_47 4:14 VDD:24 2.48114e-20
C12_48 4:15 VDD:24 1.99121e-20
C12_49 4:18 VDD:24 3.01108e-20
C12_50 4:28 VDD:24 3.51022e-20
C12_51 4:29 VDD:24 2.28626e-20
C12_52 4:16 VDD:25 1.52324e-20
C12_53 4:15 VDD:26 3.89621e-19
C12_54 4:28 VDD:26 2.28343e-19
C12_55 4:29 VDD:26 1.80726e-19
C12_56 4:30 VDD:26 5.51243e-21
C12_57 M8:DRN VDD:27 2.48114e-20
C12_58 4:28 VDD:27 5.05886e-19
C12_59 M10:DRN VDD:28 2.13821e-20
C12_60 4:28 VDD:28 6.53731e-20
C12_61 4:9 Y:12 2.19599e-19
C12_62 4:10 Y:12 2.30271e-19
C12_63 4:11 Y:12 1.95671e-19
C12_64 4:16 Y:12 2.90465e-19
C12_65 4:28 Y:12 4.3548e-19
C12_66 4:29 Y:12 1.48213e-18
C12_67 4:30 Y:12 6.95271e-19
C12_68 4:28 A:10 9.85772e-19
C12_69 4:29 A:10 9.23292e-20
C12_70 4:28 B:4 4.32832e-21
C12_71 4:28 B:6 9.39598e-20
C12_72 4:28 B:7 7.66621e-20
C12_73 4:28 B:8 2.64276e-20
C12_74 M10:DRN B:9 1.71316e-20
C12_75 4:13 B:9 1.6205e-18
C12_76 4:28 B:9 7.2186e-20
C12_77 4:13 B:11 1.03961e-19
C12_78 4:28 B:11 1.68759e-18
C12_79 4:28 C:4 4.87399e-21
C12_80 4:28 C:6 5.11476e-20
C12_81 4:28 C:7 5.16341e-20
C12_82 4:28 C:8 1.9335e-20
C12_83 4:28 C:9 1.23172e-19
C12_84 4:13 C:11 3.53609e-20
C12_85 4:17 C:11 1.53602e-20
C12_86 4:28 C:11 1.6584e-18
C12_87 4:29 C:11 2.96747e-19
C12_88 4:30 C:11 2.91594e-20
C12_89 4:29 D:5 1.33321e-19
C12_90 4:14 D:6 1.83918e-19
C12_91 4:28 D:6 8.76129e-20
C12_92 4:29 D:6 1.1565e-19
C12_93 4:28 D:7 7.1337e-20
C12_94 4:28 D:8 2.49185e-20
C12_95 M8:DRN D:9 1.65859e-20
C12_96 4:14 D:9 1.6205e-18
C12_97 4:28 D:9 1.24808e-19
C12_98 4:30 D:9 1.84403e-19
C12_99 4:14 D:11 1.03961e-19
C12_100 4:28 D:11 1.68301e-18
C12_101 4:29 D:11 2.66401e-18
C12_102 4:30 D:11 4.31311e-19
Cg12_103 4:8 VSS 1.00945e-19
Cg12_104 4:10 VSS 9.8281e-19
Cg12_105 4:12 VSS 1.68609e-19
Cg12_106 4:13 VSS 3.35981e-19
Cg12_107 4:14 VSS 3.17072e-19
Cg12_108 4:15 VSS 2.93771e-19
Cg12_109 4:16 VSS 4.69737e-19
Cg12_110 4:17 VSS 2.55987e-19
Cg12_111 4:18 VSS 2.31761e-19
Cg12_112 4:19 VSS 1.78742e-19
Cg12_113 4:28 VSS 1.76317e-18
Cg12_114 4:29 VSS 1.5216e-18
Cg12_115 4:30 VSS 7.26777e-19
R12_1 M1:GATE 4:9 7.57576
R12_2 M1:GATE 4:8 7.57576
R12_3 M10:DRN 4:13 30000.0
R12_4 M10:DRN 4:33 20089.3
R12_5 M10:DRN 4:17 59210.5
R12_6 M10:DRN 4:23 30000.0
R12_7 M2:DRN 4:19 30000.0
R12_8 M2:DRN 4:15 30000.0
R12_9 M2:DRN 4:27 15000.0
R12_10 M6:GATE 4:11 7.57576
R12_11 M6:GATE 4:10 7.57576
R12_12 M7:SRC 4:14 30000.0
R12_13 M7:SRC 4:34 20089.3
R12_14 M7:SRC 4:18 59210.5
R12_15 M7:SRC 4:25 30000.0
R12_16 M8:DRN 4:14 30000.0
R12_17 M8:DRN 4:34 20089.3
R12_18 M8:DRN 4:18 59210.5
R12_19 M8:DRN 4:25 30000.0
R12_20 M9:SRC 4:13 30000.0
R12_21 M9:SRC 4:33 20089.3
R12_22 M9:SRC 4:17 59210.5
R12_23 M9:SRC 4:23 30000.0
R12_24 4:8 4:31 5.55556
R12_25 4:9 4:16 10.6061
R12_26 4:10 4:16 10.6061
R12_27 4:11 4:12 5.55556
R12_28 4:13 4:23 14.1199
R12_29 4:13 4:33 8.62446
R12_30 4:14 4:25 14.1199
R12_31 4:14 4:34 8.62446
R12_32 4:15 4:27 9.78801
R12_33 4:16 4:21 27.7339
R12_34 4:17 4:23 5.45702
R12_35 4:18 4:25 5.45702
R12_36 4:19 4:27 9.78801
R12_37 4:20 4:21 63.5281
R12_38 4:20 4:29 25.0832
R12_39 4:20 4:30 3.58332
R12_40 4:21 4:32 7.92396
R12_41 4:22 4:23 63.5281
R12_42 4:22 4:35 3.58332
R12_43 4:22 4:24 50.1665
R12_44 4:23 4:33 21900.0
R12_45 4:24 4:25 63.5281
R12_46 4:24 4:28 25.0832
R12_47 4:25 4:34 21900.0
R12_48 4:26 4:27 63.5281
R12_49 4:26 4:36 5.9722
R12_50 4:26 4:29 21.4999
R12_51 4:28 4:29 25.8596

*|NET _generated_15 2.86348e-06PF
C13_1 _generated_15:1 VSS:18 6.61239e-19
C13_2 _generated_15:1 VSS:23 2.25577e-20
C13_3 _generated_15:1 VSS:24 3.44976e-19
C13_4 _generated_15:1 A:10 3.06042e-19
Cg13_5 _generated_15:1 VSS 9.49624e-19
R13_1 _generated_15:1 _generated_15:2 28.2828

*|NET _generated_16 3.08088e-06PF
C14_1 _generated_16:1 VSS:15 1.47021e-19
C14_2 _generated_16:1 VSS:18 5.65589e-19
C14_3 _generated_16:1 VDD 4.89892e-20
C14_4 _generated_16:1 VDD:18 1.18927e-19
C14_5 _generated_16:1 VDD:28 3.74453e-19
C14_6 _generated_16:1 A:10 3.15962e-19
C14_7 _generated_16:1 _generated_15:1 5.79044e-19
Cg14_8 _generated_16:1 VSS 9.3089e-19
R14_1 _generated_16:1 _generated_16:2 28.2828

*|NET _generated_17 3.972e-06PF
C15_1 _generated_17:1 VSS:15 9.232e-19
C15_2 _generated_17:1 VSS:18 1.76795e-19
C15_3 _generated_17:1 VSS:23 7.90689e-20
C15_4 _generated_17:1 D:4 5.09167e-19
C15_5 _generated_17:1 4:8 3.12363e-20
C15_6 _generated_17:1 4:9 4.74065e-20
C15_7 _generated_17:1 4:10 9.05603e-20
C15_8 _generated_17:1 4:15 1.66608e-19
C15_9 _generated_17:1 4:30 1.76955e-19
Cg15_10 _generated_17:1 VSS 1.19133e-18
R15_1 _generated_17:1 _generated_17:2 28.2828

*|NET _generated_18 3.12718e-06PF
C16_1 _generated_18:1 VSS:18 3.79868e-19
C16_2 _generated_18:1 VDD 9.50481e-20
C16_3 _generated_18:1 VDD:18 5.04056e-19
C16_4 _generated_18:1 4:10 1.82326e-19
C16_5 _generated_18:1 4:11 4.74065e-20
C16_6 _generated_18:1 4:12 3.10326e-20
C16_7 _generated_18:1 4:30 3.77838e-20
C16_8 _generated_18:1 _generated_17:1 5.79666e-19
Cg16_9 _generated_18:1 VSS 1.26999e-18
R16_1 _generated_18:1 _generated_18:2 28.2828

*|NET _generated_19 5.30884e-06PF
C17_1 _generated_19:1 VSS:15 4.62142e-19
C17_2 _generated_19:1 VSS:18 2.98844e-20
C17_3 _generated_19:1 VSS:23 8.26703e-20
C17_4 _generated_19:1 Y:4 3.81915e-19
C17_5 _generated_19:1 Y:12 5.50527e-20
C17_6 _generated_19:1 4:8 4.75026e-20
C17_7 _generated_19:1 4:10 2.39886e-19
Cg17_8 _generated_19:1 VSS 3.40563e-18
R17_1 _generated_19:1 _generated_19:2 28.2828

*|NET _generated_20 4.9671e-06PF
C18_1 _generated_20:1 VDD 1.91825e-19
C18_2 _generated_20:1 VDD:18 1.1978e-19
C18_3 _generated_20:1 Y:5 3.81915e-19
C18_4 _generated_20:1 Y:12 5.95758e-20
C18_5 _generated_20:1 4:10 2.39886e-19
C18_6 _generated_20:1 4:12 4.75026e-20
C18_7 _generated_20:1 _generated_19:1 6.0415e-19
Cg18_8 _generated_20:1 VSS 3.32246e-18
R18_1 _generated_20:1 _generated_20:2 28.2828

*
* Instance Section
*
MM1 M1:DRN M1:GATE M1:SRC VSS NMOS_LVT l=0.012u w=0.03u NF=1
MM10 M10:DRN M10:GATE M10:SRC VDD PMOS_LVT l=0.012u w=0.03u NF=1
MM2 M2:DRN M2:GATE M2:SRC VSS NMOS_LVT l=0.012u w=0.03u NF=1
MM3 M3:DRN M3:GATE M3:SRC VSS NMOS_LVT l=0.012u w=0.03u NF=1
MM4 M4:DRN M4:GATE M4:SRC VSS NMOS_LVT l=0.012u w=0.03u NF=1
MM5 M5:DRN M5:GATE M5:SRC VSS NMOS_LVT l=0.012u w=0.03u NF=1
MM6 M6:DRN M6:GATE M6:SRC VDD PMOS_LVT l=0.012u w=0.03u NF=1
MM7 M7:DRN M7:GATE M7:SRC VDD PMOS_LVT l=0.012u w=0.03u NF=1
MM8 M8:DRN M8:GATE M8:SRC VDD PMOS_LVT l=0.012u w=0.03u NF=1
MM9 M9:DRN M9:GATE M9:SRC VDD PMOS_LVT l=0.012u w=0.03u NF=1

.ENDS
