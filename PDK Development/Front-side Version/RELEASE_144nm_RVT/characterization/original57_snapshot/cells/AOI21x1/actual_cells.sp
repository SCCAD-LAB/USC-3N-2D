*
*|DSPF 1.3
*|DESIGN AOI21x1
*|DATE "Tue Nov  3 20:50:56 2026"
*|VENDOR "Synopsys"
*|PROGRAM "StarRC"
*|VERSION "X-2025.06-SP1"
*|DIVIDER /
*|DELIMITER :
**FORMAT SPF
*

** COMMENTS

** OPERATING_TEMPERATURE 25
** GLOBAL_TEMPERATURE 25
**
** TCAD_GRD_FILE /cedar/cedar_coe/ece-limsk/yhuang861/GRO/.planning/experiments_migrated_20261022/usc144_github_release_20261103/sources/github_FSPR.nxtgrd
**   TCAD_TIME_STAMP Tue Mar 31 05:07:55 2026
**   TCADGRD_VERSION 89

.SUBCKT AOI21x1 VSS VDD Y A B C

*|GROUND_NET VSS

*|NET VSS 6.81272e-05PF
*|P (VSS B 0 0.0840 0.0000)
*|I (M1:DRN M1 DRN B 0 0.1320 0.0360)
*|I (M3:SRC M3 SRC B 0 0.0360 0.0360)
Cg1_1 VSS:4 VSS 2.52098e-19
Cg1_2 VSS:5 VSS 1.78742e-19
Cg1_3 VSS:12 VSS 2.399e-18
Cg1_4 VSS:13 VSS 2.45608e-17
Cg1_5 VSS:16 VSS 4.37685e-18
Cg1_6 VSS:18 VSS 5.71152e-18
Cg1_7 VSS:19 VSS 4.73669e-19
R1_1 VSS VSS:9 12.5416
R1_2 VSS VSS:7 12.5416
R1_3 M1:DRN VSS:15 30000.0
R1_4 M1:DRN VSS:5 30000.0
R1_5 M1:DRN VSS:24 15000.0
R1_6 M3:SRC VSS:14 30000.0
R1_7 M3:SRC VSS:4 30000.0
R1_8 M3:SRC VSS:22 15000.0
R1_9 VSS:4 VSS:22 7.8411
R1_10 VSS:4 VSS:19 12.4587
R1_11 VSS:5 VSS:24 7.8411
R1_12 VSS:5 VSS:12 12.4587
R1_13 VSS:6 VSS:18 17.9166
R1_14 VSS:6 VSS:7 25.0832
R1_15 VSS:6 VSS:19 31.764
R1_16 VSS:7 VSS:8 63.5281
R1_17 VSS:8 VSS:19 50.1851
R1_18 VSS:8 VSS:10 55.4677
R1_19 VSS:9 VSS:10 63.5281
R1_20 VSS:9 VSS:11 25.0832
R1_21 VSS:10 VSS:12 50.1851
R1_22 VSS:11 VSS:12 31.764
R1_23 VSS:11 VSS:26 17.9166
R1_24 VSS:12 VSS:21 34.3372
R1_25 VSS:13 VSS:16 7112.68
R1_26 VSS:14 VSS:22 7.8411
R1_27 VSS:14 VSS:23 1.77981
R1_28 VSS:15 VSS:24 7.8411
R1_29 VSS:15 VSS:25 1.77981
R1_30 VSS:16 VSS:17 2057.93
R1_31 VSS:19 VSS:20 34.3372
R1_32 VSS:19 VSS:13 0.01

*|NET VDD 3.69374e-05PF
*|P (VDD B 0 0.0840 0.1440)
*|I (M5:SRC M5 SRC B 0 0.0780 0.1080)
*|I (M6:DRN M6 DRN B 0 0.0480 0.1080)
C2_1 VDD VSS:12 7.80663e-20
C2_2 VDD:8 VSS:12 3.83957e-20
C2_3 VDD VSS:13 1.13237e-18
C2_4 VDD:4 VSS:13 8.02037e-19
C2_5 VDD:8 VSS:13 1.31353e-18
C2_6 VDD VSS:18 6.62389e-19
C2_7 VDD:8 VSS:18 2.76282e-20
Cg2_8 VDD VSS 6.14039e-18
Cg2_9 VDD:4 VSS 2.80944e-19
Cg2_10 VDD:8 VSS 9.69047e-18
R2_1 VDD VDD:7 12.5416
R2_2 VDD VDD:9 12.5416
R2_3 VDD VDD:13 0.1
R2_4 M5:SRC VDD:14 30000.0
R2_5 M5:SRC VDD:4 30000.0
R2_6 M5:SRC VDD:17 15000.0
R2_7 M6:DRN VDD:14 30000.0
R2_8 M6:DRN VDD:4 30000.0
R2_9 M6:DRN VDD:17 15000.0
R2_10 VDD:4 VDD:17 7.84041
R2_11 VDD:4 VDD:18 1.77981
R2_12 VDD:5 VDD:6 63.5281
R2_13 VDD:5 VDD:19 17.9166
R2_14 VDD:5 VDD:7 25.0832
R2_15 VDD:6 VDD:15 39.6198
R2_16 VDD:6 VDD:8 50.1851
R2_17 VDD:7 VDD:8 31.764
R2_18 VDD:8 VDD:10 50.1851
R2_19 VDD:8 VDD:14 12.4587
R2_20 VDD:9 VDD:10 63.5281
R2_21 VDD:9 VDD:11 25.0832
R2_22 VDD:10 VDD:12 55.4677
R2_23 VDD:11 VDD:12 63.5281
R2_24 VDD:11 VDD:20 17.9166
R2_25 VDD:12 VDD:16 39.6198
R2_26 VDD:14 VDD:17 7.84041

*|NET Y 2.90113e-05PF
*|P (Y B 0 0.1470 0.0720)
*|I (M1:SRC M1 SRC B 0 0.1200 0.0360)
*|I (M2:DRN M2 DRN B 0 0.0900 0.0360)
*|I (M4:DRN M4 DRN B 0 0.1320 0.1080)
C3_1 Y:13 VSS:5 1.32169e-19
C3_2 Y:14 VSS:5 1.52743e-19
C3_3 M2:DRN VSS:12 2.09115e-20
C3_4 M4:DRN VSS:12 1.79419e-20
C3_5 Y:5 VSS:12 2.32373e-18
C3_6 Y:6 VSS:12 3.79104e-19
C3_7 Y:13 VSS:12 4.40773e-19
C3_8 Y:14 VSS:12 5.69137e-19
C3_9 Y:13 VSS:13 1.02535e-19
C3_10 Y:14 VSS:13 5.68629e-19
C3_11 Y:5 VSS:15 3.27859e-20
C3_12 Y:7 VSS:15 3.00786e-20
C3_13 Y:13 VSS:15 3.99736e-20
C3_14 Y:14 VSS:15 2.27223e-20
C3_15 Y:13 VSS:16 1.09055e-19
C3_16 Y:13 VSS:17 9.73654e-20
C3_17 Y:14 VSS:17 9.27835e-20
C3_18 Y:5 VSS:18 1.24933e-19
C3_19 Y:13 VSS:18 4.19046e-18
C3_20 Y:14 VSS:18 9.99526e-20
C3_21 Y:6 VDD 2.62584e-19
C3_22 Y:13 VDD 2.99343e-19
C3_23 Y:14 VDD 1.43694e-18
C3_24 Y:6 VDD:8 1.05946e-18
Cg3_25 M2:DRN VSS 1.72125e-20
Cg3_26 Y:5 VSS 3.5022e-19
Cg3_27 Y:6 VSS 2.8933e-19
Cg3_28 Y:7 VSS 2.31922e-19
Cg3_29 Y:8 VSS 1.78742e-19
Cg3_30 Y:13 VSS 1.19138e-18
Cg3_31 Y:14 VSS 2.60219e-18
R3_1 Y Y:11 21.4999
R3_2 Y Y:13 25.7999
R3_3 M1:SRC Y:7 30000.0
R3_4 M1:SRC Y:15 20270.3
R3_5 M1:SRC Y:5 57692.3
R3_6 M1:SRC Y:10 30000.0
R3_7 M2:DRN Y:7 30000.0
R3_8 M2:DRN Y:15 20270.3
R3_9 M2:DRN Y:5 57692.3
R3_10 M2:DRN Y:10 30000.0
R3_11 M4:DRN Y:8 30000.0
R3_12 M4:DRN Y:6 30000.0
R3_13 M4:DRN Y:12 15000.0
R3_14 Y:5 Y:10 5.51634
R3_15 Y:6 Y:12 9.78801
R3_16 Y:7 Y:10 14.0605
R3_17 Y:7 Y:15 49500.0
R3_18 Y:8 Y:12 9.78801
R3_19 Y:9 Y:10 63.5281
R3_20 Y:9 Y:16 3.58332
R3_21 Y:9 Y:13 25.0832
R3_22 Y:10 Y:15 3.7634
R3_23 Y:11 Y:12 63.5281
R3_24 Y:11 Y:14 7.94303

*|NET A 1.92827e-05PF
*|P (A B 0 0.0210 0.0720)
*|I (M3:GATE M3 GATE I 3.6e-19 0.0420 0.0360)
*|I (M6:GATE M6 GATE I 3.6e-19 0.0420 0.1080)
C4_1 A:5 VSS:4 1.24456e-18
C4_2 A:11 VSS:4 2.33814e-19
C4_3 A:4 VSS:12 4.61602e-19
C4_4 A:5 VSS:12 7.89427e-21
C4_5 A:11 VSS:12 9.64013e-20
C4_6 A:11 VSS:13 6.2498e-19
C4_7 A:11 VSS:14 5.97872e-20
C4_8 A:4 VSS:18 3.09329e-20
C4_9 A:11 VSS:18 1.46398e-18
C4_10 A:5 VSS:19 6.89692e-19
C4_11 A:6 VSS:19 1.83918e-19
C4_12 A:9 VSS:19 9.1614e-19
C4_13 A:11 VSS:19 6.1162e-19
Cg4_14 A:4 VSS 2.38318e-19
Cg4_15 A:6 VSS 3.4119e-19
Cg4_16 A:8 VSS 3.87511e-19
Cg4_17 A:9 VSS 2.00222e-19
Cg4_18 A:11 VSS 2.87387e-18
R4_1 A A:11 29.3832
R4_2 A A:14 12.8402
R4_3 A A:10 63.5281
R4_4 M3:GATE A:5 7.57576
R4_5 M3:GATE A:4 7.57576
R4_6 M6:GATE A:7 7.57576
R4_7 M6:GATE A:6 7.57576
R4_8 A:4 A:12 5.55556
R4_9 A:5 A:9 10.6061
R4_10 A:6 A:9 10.6061
R4_11 A:7 A:8 5.55556
R4_12 A:9 A:10 27.7339
R4_13 A:10 A:13 7.92396

*|NET B 1.67386e-05PF
*|P (B B 0 0.0630 0.0720)
*|I (M2:GATE M2 GATE I 3.6e-19 0.0840 0.0360)
*|I (M5:GATE M5 GATE I 3.6e-19 0.0840 0.1080)
C5_1 B:11 VSS:4 8.37832e-20
C5_2 B:4 VSS:12 4.62275e-19
C5_3 B:5 VSS:12 7.89427e-21
C5_4 B:11 VSS:12 8.83916e-20
C5_5 B:11 VSS:13 2.226e-19
C5_6 B:11 VSS:16 2.65282e-20
C5_7 B:4 VSS:18 9.76367e-20
C5_8 B:11 VSS:18 1.57773e-18
C5_9 B:4 VSS:19 3.93596e-22
C5_10 B:11 VSS:19 1.05423e-19
C5_11 B:8 VDD 5.14487e-20
C5_12 B:11 VDD 1.63451e-19
C5_13 B:6 VDD:8 1.83918e-19
C5_14 B:8 VDD:8 1.15217e-19
C5_15 B:9 VDD:8 1.62973e-18
C5_16 B:11 VDD:8 1.12105e-19
C5_17 B:9 VDD:14 1.71158e-20
C5_18 B:5 Y:13 5.98514e-20
C5_19 B:11 Y:13 8.71287e-19
C5_20 B:11 Y:14 3.9442e-19
C5_21 B:4 A:4 5.06565e-19
C5_22 B:11 A:4 1.49976e-20
C5_23 B:11 A:5 1.16886e-19
C5_24 B:11 A:6 1.7832e-19
C5_25 B:11 A:11 3.15727e-18
Cg5_26 B:4 VSS 1.00471e-19
Cg5_27 B:6 VSS 3.4119e-19
Cg5_28 B:8 VSS 2.27134e-19
Cg5_29 B:9 VSS 1.63308e-19
Cg5_30 B:11 VSS 1.25367e-18
R5_1 B B:11 29.3832
R5_2 B B:14 12.8402
R5_3 B B:10 63.5281
R5_4 M2:GATE B:5 7.57576
R5_5 M2:GATE B:4 7.57576
R5_6 M5:GATE B:7 7.57576
R5_7 M5:GATE B:6 7.57576
R5_8 B:4 B:12 5.55556
R5_9 B:5 B:9 10.6061
R5_10 B:6 B:9 10.6061
R5_11 B:7 B:8 5.55556
R5_12 B:9 B:10 27.7339
R5_13 B:10 B:13 7.92396

*|NET C 2.08262e-05PF
*|P (C B 0 0.1050 0.0720)
*|I (M1:GATE M1 GATE I 3.6e-19 0.1260 0.0360)
*|I (M4:GATE M4 GATE I 3.6e-19 0.1260 0.1080)
C6_1 C:4 VSS:12 4.68614e-19
C6_2 C:5 VSS:12 7.89427e-21
C6_3 C:11 VSS:13 1.80512e-19
C6_4 C:4 VSS:18 6.0924e-20
C6_5 C:11 VSS:18 1.47252e-19
C6_6 C:4 Y:5 1.82222e-19
C6_7 C:5 Y:5 6.87765e-19
C6_8 C:6 Y:5 1.83918e-19
C6_9 C:9 Y:5 9.60833e-19
C6_10 C:11 Y:5 3.89081e-19
C6_11 C:5 Y:7 1.22788e-18
C6_12 C:5 Y:13 8.04372e-20
C6_13 C:6 Y:13 1.24019e-19
C6_14 C:11 Y:13 1.58391e-18
C6_15 C:5 Y:14 8.84138e-20
C6_16 C:6 Y:14 2.24305e-19
C6_17 C:7 Y:14 1.61487e-19
C6_18 C:9 Y:14 2.90465e-19
C6_19 C:11 Y:14 2.05322e-18
C6_20 C:4 B:4 4.50387e-20
C6_21 C:11 B:5 2.44421e-20
C6_22 C:11 B:6 1.83969e-19
C6_23 C:11 B:11 1.97534e-18
Cg6_24 C:4 VSS 1.01481e-19
Cg6_25 C:6 VSS 9.8281e-19
Cg6_26 C:8 VSS 3.86692e-19
Cg6_27 C:9 VSS 4.82576e-19
Cg6_28 C:11 VSS 1.29402e-18
R6_1 C C:11 12.8402
R6_2 C C:14 12.8402
R6_3 C C:10 63.5281
R6_4 M1:GATE C:5 7.57576
R6_5 M1:GATE C:4 7.57576
R6_6 M4:GATE C:7 7.57576
R6_7 M4:GATE C:6 7.57576
R6_8 C:4 C:12 5.55556
R6_9 C:5 C:9 10.6061
R6_10 C:6 C:9 10.6061
R6_11 C:7 C:8 5.55556
R6_12 C:9 C:10 27.7339
R6_13 C:10 C:13 7.92396

*|NET 11 8.38056e-07PF
*|I (M2:SRC M2 SRC B 0 0.0780 0.0360)
*|I (M3:DRN M3 DRN B 0 0.0480 0.0360)
C8_1 M3:DRN VSS:4 2.82443e-20
C8_2 M3:DRN VSS:12 4.65606e-19
C8_3 M3:DRN VSS:18 1.17881e-19
C8_4 M3:DRN VSS:19 3.25301e-20
C8_5 M3:DRN B:11 1.93794e-19
R8_1 M2:SRC M3:DRN 15000.0

*|NET 4 3.04861e-05PF
*|I (M4:SRC M4 SRC B 0 0.1200 0.1080)
*|I (M5:DRN M5 DRN B 0 0.0900 0.1080)
*|I (M6:SRC M6 SRC B 0 0.0360 0.1080)
C9_1 M6:SRC VSS:12 6.41291e-21
C9_2 4:4 VSS:12 6.27538e-20
C9_3 4:4 VSS:13 8.82123e-19
C9_4 4:6 VSS:13 8.02037e-19
C9_5 4:12 VSS:13 5.91837e-19
C9_6 4:12 VSS:18 5.97369e-19
C9_7 M6:SRC VSS:19 3.59134e-21
C9_8 4:4 VSS:19 1.20567e-19
C9_9 4:12 VSS:19 3.13305e-21
C9_10 4:4 VDD 3.0241e-19
C9_11 4:5 VDD 2.58546e-19
C9_12 4:12 VDD 7.01053e-18
C9_13 M5:DRN VDD:4 3.01108e-20
C9_14 4:12 VDD:4 2.10875e-19
C9_15 M5:DRN VDD:8 2.48114e-20
C9_16 4:4 VDD:8 1.4613e-18
C9_17 4:5 VDD:8 1.19561e-18
C9_18 4:12 VDD:8 3.73568e-19
C9_19 4:4 VDD:14 2.48114e-20
C9_20 4:6 VDD:14 3.01108e-20
C9_21 4:12 VDD:14 5.1161e-20
C9_22 4:5 M4:DRN 3.62152e-20
C9_23 4:7 M4:DRN 3.01108e-20
C9_24 M5:DRN Y:5 3.52036e-21
C9_25 4:5 Y:5 1.27884e-19
C9_26 4:12 Y:13 7.69021e-20
C9_27 4:5 Y:14 1.4029e-19
C9_28 4:7 Y:14 1.01831e-19
C9_29 4:12 Y:14 1.02232e-18
C9_30 4:4 A:6 1.83918e-19
C9_31 4:12 A:6 4.52798e-20
C9_32 4:12 A:7 4.47114e-20
C9_33 4:12 A:8 1.73732e-20
C9_34 M6:SRC A:9 1.45522e-20
C9_35 4:4 A:9 1.63137e-18
C9_36 4:12 A:9 5.11249e-20
C9_37 M6:SRC A:11 1.63447e-20
C9_38 4:4 A:11 1.21417e-19
C9_39 4:6 A:11 2.03074e-21
C9_40 4:12 A:11 1.69175e-18
C9_41 4:12 B:6 5.62864e-20
C9_42 4:12 B:7 5.16341e-20
C9_43 4:12 B:8 1.9335e-20
C9_44 4:12 B:9 1.23172e-19
C9_45 4:4 B:11 3.53609e-20
C9_46 4:6 B:11 1.53602e-20
C9_47 4:12 B:11 1.68381e-18
C9_48 4:5 C:6 1.83918e-19
C9_49 4:5 C:7 6.89418e-19
C9_50 4:7 C:7 1.24381e-18
C9_51 4:12 C:7 7.74548e-20
C9_52 4:5 C:8 1.83918e-19
C9_53 M5:DRN C:9 1.40231e-20
C9_54 4:5 C:9 1.6343e-18
C9_55 4:12 C:9 1.69431e-20
C9_56 4:5 C:11 1.03961e-19
C9_57 4:12 C:11 1.57007e-18
Cg9_58 M6:SRC VSS 5.43919e-21
Cg9_59 4:4 VSS 3.54682e-19
Cg9_60 4:5 VSS 3.28787e-19
Cg9_61 4:6 VSS 2.55987e-19
Cg9_62 4:7 VSS 2.40153e-19
Cg9_63 4:12 VSS 1.69416e-18
R9_1 M4:SRC 4:5 30000.0
R9_2 M4:SRC 4:14 20089.3
R9_3 M4:SRC 4:7 59210.5
R9_4 M4:SRC 4:11 30000.0
R9_5 M5:DRN 4:5 30000.0
R9_6 M5:DRN 4:14 20089.3
R9_7 M5:DRN 4:7 59210.5
R9_8 M5:DRN 4:11 30000.0
R9_9 M6:SRC 4:4 30000.0
R9_10 M6:SRC 4:13 20089.3
R9_11 M6:SRC 4:6 59210.5
R9_12 M6:SRC 4:9 30000.0
R9_13 4:4 4:9 14.1199
R9_14 4:4 4:13 8.62521
R9_15 4:5 4:11 14.1199
R9_16 4:5 4:14 8.62446
R9_17 4:6 4:9 5.45756
R9_18 4:7 4:11 5.45702
R9_19 4:8 4:9 63.5281
R9_20 4:8 4:12 3.58332
R9_21 4:8 4:10 50.1665
R9_22 4:9 4:13 43800.0
R9_23 4:10 4:11 63.5281
R9_24 4:10 4:15 3.58332
R9_25 4:11 4:14 21900.0

*|NET _generated_12 2.95652e-06PF
C10_1 _generated_12:1 VSS:13 5.19939e-19
C10_2 _generated_12:1 VSS:16 2.43246e-20
C10_3 _generated_12:1 VSS:18 2.25577e-20
C10_4 _generated_12:1 VSS:19 3.44976e-19
C10_5 _generated_12:1 A:5 1.08527e-19
C10_6 _generated_12:1 A:6 1.01484e-19
C10_7 _generated_12:1 A:11 3.06042e-19
Cg10_8 _generated_12:1 VSS 9.49624e-19
R10_1 _generated_12:1 _generated_12:2 28.2828

*|NET _generated_13 3.22737e-06PF
C11_1 _generated_13:1 VSS:12 1.47021e-19
C11_2 _generated_13:1 VSS:13 5.88423e-19
C11_3 _generated_13:1 VDD 5.00228e-20
C11_4 _generated_13:1 VDD:8 1.18927e-19
C11_5 _generated_13:1 A:6 1.5545e-19
C11_6 _generated_13:1 A:11 1.50877e-19
C11_7 _generated_13:1 4:4 3.45631e-19
C11_8 _generated_13:1 4:12 1.5589e-19
C11_9 _generated_13:1 _generated_12:1 5.79044e-19
Cg11_10 _generated_13:1 VSS 9.3608e-19
R11_1 _generated_13:1 _generated_13:2 28.2828

*|NET _generated_14 5.36589e-06PF
C12_1 _generated_14:1 VSS:12 9.21148e-19
C12_2 _generated_14:1 VSS:13 2.98844e-20
C12_3 _generated_14:1 VSS:18 9.68154e-20
C12_4 _generated_14:1 C:4 1.58022e-21
C12_5 _generated_14:1 C:6 2.39886e-19
Cg12_6 _generated_14:1 VSS 3.47243e-18
R12_1 _generated_14:1 _generated_14:2 28.2828

*|NET _generated_15 4.95268e-06PF
C13_1 _generated_15:1 VDD 1.77679e-19
C13_2 _generated_15:1 VDD:8 1.19386e-19
C13_3 _generated_15:1 Y:6 3.81915e-19
C13_4 _generated_15:1 Y:14 5.9697e-20
C13_5 _generated_15:1 C:6 2.39886e-19
C13_6 _generated_15:1 C:8 4.75026e-20
C13_7 _generated_15:1 _generated_14:1 6.0415e-19
Cg13_8 _generated_15:1 VSS 3.32246e-18
R13_1 _generated_15:1 _generated_15:2 28.2828

*
* Instance Section
*
MM1 M1:DRN M1:GATE M1:SRC VSS NMOS_LVT l=0.012u w=0.03u NF=1
MM2 M2:DRN M2:GATE M2:SRC VSS NMOS_LVT l=0.012u w=0.03u NF=1
MM3 M3:DRN M3:GATE M3:SRC VSS NMOS_LVT l=0.012u w=0.03u NF=1
MM4 M4:DRN M4:GATE M4:SRC VDD PMOS_LVT l=0.012u w=0.03u NF=1
MM5 M5:DRN M5:GATE M5:SRC VDD PMOS_LVT l=0.012u w=0.03u NF=1
MM6 M6:DRN M6:GATE M6:SRC VDD PMOS_LVT l=0.012u w=0.03u NF=1

.ENDS
