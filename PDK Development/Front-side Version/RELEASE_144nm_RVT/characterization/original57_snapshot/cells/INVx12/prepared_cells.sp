*
*|DSPF 1.3
*|DESIGN INVx12
*|DATE "Tue Nov  3 20:49:59 2026"
*|VENDOR "Synopsys"
*|PROGRAM "StarRC"
*|VERSION "X-2025.06-SP1"
*|DIVIDER /
*|DELIMITER :
**FORMAT SPF
*

** COMMENTS

** OPERATING_TEMPERATURE 25
** GLOBAL_TEMPERATURE 25
**
** TCAD_GRD_FILE /cedar/cedar_coe/ece-limsk/yhuang861/GRO/.planning/experiments_migrated_20261022/usc144_github_release_20261103/sources/github_FSPR.nxtgrd
**   TCAD_TIME_STAMP Tue Mar 31 05:07:55 2026
**   TCADGRD_VERSION 89

.SUBCKT INVx12 VSS VDD A Y

*|GROUND_NET VSS

*|NET VSS 0.000113435PF
*|P (VSS B 0 0.2730 0.0000)
*|I (M1:DRN M1 DRN B 0 0.5100 0.0360)
*|I (M10:SRC M10 SRC B 0 0.1200 0.0360)
*|I (M11:DRN M11 DRN B 0 0.0900 0.0360)
*|I (M12:SRC M12 SRC B 0 0.0360 0.0360)
*|I (M2:SRC M2 SRC B 0 0.4560 0.0360)
*|I (M3:DRN M3 DRN B 0 0.4260 0.0360)
*|I (M4:SRC M4 SRC B 0 0.3720 0.0360)
*|I (M5:DRN M5 DRN B 0 0.3420 0.0360)
*|I (M6:SRC M6 SRC B 0 0.2880 0.0360)
*|I (M7:DRN M7 DRN B 0 0.2580 0.0360)
*|I (M8:SRC M8 SRC B 0 0.2040 0.0360)
*|I (M9:DRN M9 DRN B 0 0.1740 0.0360)
Cg1_1 VSS:14 VSS 2.68769e-19
Cg1_2 VSS:15 VSS 2.77026e-19
Cg1_3 VSS:16 VSS 2.77026e-19
Cg1_4 VSS:17 VSS 2.77026e-19
Cg1_5 VSS:18 VSS 2.77026e-19
Cg1_6 VSS:19 VSS 2.77026e-19
Cg1_7 VSS:20 VSS 1.78742e-19
Cg1_8 VSS:27 VSS 4.41132e-18
Cg1_9 VSS:35 VSS 1.47383e-17
Cg1_10 VSS:36 VSS 6.21352e-19
Cg1_11 VSS:37 VSS 5.30645e-19
Cg1_12 VSS:38 VSS 4.99306e-19
Cg1_13 VSS:39 VSS 4.61252e-19
Cg1_14 VSS:40 VSS 5.27661e-19
Cg1_15 VSS:41 VSS 4.88134e-19
R1_1 VSS VSS:23 50.1665
R1_2 VSS VSS:24 50.1665
R1_3 VSS VSS:38 31.764
R1_4 M1:DRN VSS:34 30000.0
R1_5 M1:DRN VSS:20 30000.0
R1_6 M1:DRN VSS:56 15000.0
R1_7 M10:SRC VSS:29 30000.0
R1_8 M10:SRC VSS:15 30000.0
R1_9 M10:SRC VSS:46 15000.0
R1_10 M11:DRN VSS:29 30000.0
R1_11 M11:DRN VSS:15 30000.0
R1_12 M11:DRN VSS:46 15000.0
R1_13 M12:SRC VSS:28 30000.0
R1_14 M12:SRC VSS:14 30000.0
R1_15 M12:SRC VSS:44 15000.0
R1_16 M2:SRC VSS:33 30000.0
R1_17 M2:SRC VSS:19 30000.0
R1_18 M2:SRC VSS:54 15000.0
R1_19 M3:DRN VSS:33 30000.0
R1_20 M3:DRN VSS:19 30000.0
R1_21 M3:DRN VSS:54 15000.0
R1_22 M4:SRC VSS:32 30000.0
R1_23 M4:SRC VSS:18 30000.0
R1_24 M4:SRC VSS:52 15000.0
R1_25 M5:DRN VSS:32 30000.0
R1_26 M5:DRN VSS:18 30000.0
R1_27 M5:DRN VSS:52 15000.0
R1_28 M6:SRC VSS:31 30000.0
R1_29 M6:SRC VSS:17 30000.0
R1_30 M6:SRC VSS:50 15000.0
R1_31 M7:DRN VSS:31 30000.0
R1_32 M7:DRN VSS:17 30000.0
R1_33 M7:DRN VSS:50 15000.0
R1_34 M8:SRC VSS:30 30000.0
R1_35 M8:SRC VSS:16 30000.0
R1_36 M8:SRC VSS:48 15000.0
R1_37 M9:DRN VSS:30 30000.0
R1_38 M9:DRN VSS:16 30000.0
R1_39 M9:DRN VSS:48 15000.0
R1_40 VSS:14 VSS:44 7.8411
R1_41 VSS:14 VSS:41 12.4587
R1_42 VSS:15 VSS:46 7.84041
R1_43 VSS:15 VSS:40 12.4587
R1_44 VSS:16 VSS:48 7.84041
R1_45 VSS:16 VSS:39 12.4587
R1_46 VSS:17 VSS:50 7.84041
R1_47 VSS:17 VSS:38 12.4587
R1_48 VSS:18 VSS:52 7.84041
R1_49 VSS:18 VSS:37 12.4587
R1_50 VSS:19 VSS:54 7.84041
R1_51 VSS:19 VSS:36 12.4587
R1_52 VSS:20 VSS:56 7.8411
R1_53 VSS:20 VSS:27 12.4587
R1_54 VSS:21 VSS:35 17.9166
R1_55 VSS:21 VSS:22 50.1665
R1_56 VSS:21 VSS:41 31.764
R1_57 VSS:22 VSS:23 50.1665
R1_58 VSS:22 VSS:40 31.764
R1_59 VSS:23 VSS:39 31.764
R1_60 VSS:24 VSS:25 50.1665
R1_61 VSS:24 VSS:37 31.764
R1_62 VSS:25 VSS:26 50.1665
R1_63 VSS:25 VSS:36 31.764
R1_64 VSS:26 VSS:27 31.764
R1_65 VSS:26 VSS:58 17.9166
R1_66 VSS:27 VSS:36 100.37
R1_67 VSS:27 VSS:43 34.3372
R1_68 VSS:28 VSS:44 7.8411
R1_69 VSS:28 VSS:45 1.77981
R1_70 VSS:29 VSS:46 7.84041
R1_71 VSS:29 VSS:47 1.77981
R1_72 VSS:30 VSS:48 7.84041
R1_73 VSS:30 VSS:49 1.77981
R1_74 VSS:31 VSS:50 7.84041
R1_75 VSS:31 VSS:51 1.77981
R1_76 VSS:32 VSS:52 7.84041
R1_77 VSS:32 VSS:53 1.77981
R1_78 VSS:33 VSS:54 7.84041
R1_79 VSS:33 VSS:55 1.77981
R1_80 VSS:34 VSS:56 7.8411
R1_81 VSS:34 VSS:57 1.77981
R1_82 VSS:36 VSS:37 100.37
R1_83 VSS:37 VSS:38 100.37
R1_84 VSS:38 VSS:39 100.37
R1_85 VSS:39 VSS:40 100.37
R1_86 VSS:40 VSS:41 100.37
R1_87 VSS:41 VSS:42 34.3372

*|NET VDD 0.000123495PF
*|P (VDD B 0 0.2730 0.1440)
*|I (M13:DRN M13 DRN B 0 0.5100 0.1080)
*|I (M14:SRC M14 SRC B 0 0.4560 0.1080)
*|I (M15:DRN M15 DRN B 0 0.4260 0.1080)
*|I (M16:SRC M16 SRC B 0 0.3720 0.1080)
*|I (M17:DRN M17 DRN B 0 0.3420 0.1080)
*|I (M18:SRC M18 SRC B 0 0.2880 0.1080)
*|I (M19:DRN M19 DRN B 0 0.2580 0.1080)
*|I (M20:SRC M20 SRC B 0 0.2040 0.1080)
*|I (M21:DRN M21 DRN B 0 0.1740 0.1080)
*|I (M22:SRC M22 SRC B 0 0.1200 0.1080)
*|I (M23:DRN M23 DRN B 0 0.0900 0.1080)
*|I (M24:SRC M24 SRC B 0 0.0360 0.1080)
C2_1 VDD:22 VSS:27 6.39187e-20
C2_2 VDD:33 VSS:27 4.19119e-19
C2_3 VDD:34 VSS:27 6.70033e-21
C2_4 VDD:40 VSS:27 2.00992e-20
C2_5 VDD:41 VSS:27 7.79004e-20
C2_6 VDD:33 VSS:35 2.76282e-20
C2_7 VDD:41 VSS:35 5.95297e-19
C2_8 VDD:31 VSS:36 4.65622e-19
C2_9 VDD:39 VSS:36 2.24891e-20
C2_10 VDD:29 VSS:37 4.65622e-19
C2_11 VDD:38 VSS:37 2.24891e-20
C2_12 VDD:27 VSS:38 4.65622e-19
C2_13 VDD:37 VSS:38 2.24891e-20
C2_14 VDD:26 VSS:39 4.65622e-19
C2_15 VDD:36 VSS:39 2.24891e-20
C2_16 VDD:24 VSS:40 4.65622e-19
C2_17 VDD:35 VSS:40 2.24891e-20
C2_18 VDD:22 VSS:41 4.49535e-19
C2_19 VDD:34 VSS:41 2.26115e-20
Cg2_20 VDD:14 VSS 2.68918e-19
Cg2_21 VDD:15 VSS 2.77231e-19
Cg2_22 VDD:16 VSS 2.77231e-19
Cg2_23 VDD:17 VSS 2.77231e-19
Cg2_24 VDD:18 VSS 2.77231e-19
Cg2_25 VDD:19 VSS 2.77231e-19
Cg2_26 VDD:20 VSS 1.78742e-19
Cg2_27 VDD:22 VSS 8.08969e-19
Cg2_28 VDD:24 VSS 8.39321e-19
Cg2_29 VDD:26 VSS 7.72908e-19
Cg2_30 VDD:27 VSS 8.10965e-19
Cg2_31 VDD:29 VSS 8.42306e-19
Cg2_32 VDD:31 VSS 8.14855e-19
Cg2_33 VDD:33 VSS 2.62777e-17
Cg2_34 VDD:34 VSS 5.43919e-21
Cg2_35 VDD:41 VSS 1.47074e-17
R2_1 VDD VDD:25 50.1665
R2_2 VDD VDD:28 50.1665
R2_3 VDD VDD:27 31.764
R2_4 M13:DRN VDD:40 30000.0
R2_5 M13:DRN VDD:20 30000.0
R2_6 M13:DRN VDD:56 15000.0
R2_7 M14:SRC VDD:39 30000.0
R2_8 M14:SRC VDD:19 30000.0
R2_9 M14:SRC VDD:54 15000.0
R2_10 M15:DRN VDD:39 30000.0
R2_11 M15:DRN VDD:19 30000.0
R2_12 M15:DRN VDD:54 15000.0
R2_13 M16:SRC VDD:38 30000.0
R2_14 M16:SRC VDD:18 30000.0
R2_15 M16:SRC VDD:52 15000.0
R2_16 M17:DRN VDD:38 30000.0
R2_17 M17:DRN VDD:18 30000.0
R2_18 M17:DRN VDD:52 15000.0
R2_19 M18:SRC VDD:37 30000.0
R2_20 M18:SRC VDD:17 30000.0
R2_21 M18:SRC VDD:50 15000.0
R2_22 M19:DRN VDD:37 30000.0
R2_23 M19:DRN VDD:17 30000.0
R2_24 M19:DRN VDD:50 15000.0
R2_25 M20:SRC VDD:36 30000.0
R2_26 M20:SRC VDD:16 30000.0
R2_27 M20:SRC VDD:48 15000.0
R2_28 M21:DRN VDD:36 30000.0
R2_29 M21:DRN VDD:16 30000.0
R2_30 M21:DRN VDD:48 15000.0
R2_31 M22:SRC VDD:35 30000.0
R2_32 M22:SRC VDD:15 30000.0
R2_33 M22:SRC VDD:46 15000.0
R2_34 M23:DRN VDD:35 30000.0
R2_35 M23:DRN VDD:15 30000.0
R2_36 M23:DRN VDD:46 15000.0
R2_37 M24:SRC VDD:34 30000.0
R2_38 M24:SRC VDD:14 30000.0
R2_39 M24:SRC VDD:44 15000.0
R2_40 VDD:14 VDD:44 7.8411
R2_41 VDD:14 VDD:45 1.77981
R2_42 VDD:15 VDD:46 7.84041
R2_43 VDD:15 VDD:47 1.77981
R2_44 VDD:16 VDD:48 7.84041
R2_45 VDD:16 VDD:49 1.77981
R2_46 VDD:17 VDD:50 7.84041
R2_47 VDD:17 VDD:51 1.77981
R2_48 VDD:18 VDD:52 7.84041
R2_49 VDD:18 VDD:53 1.77981
R2_50 VDD:19 VDD:54 7.84041
R2_51 VDD:19 VDD:55 1.77981
R2_52 VDD:20 VDD:56 7.8411
R2_53 VDD:20 VDD:57 1.77981
R2_54 VDD:21 VDD:22 31.764
R2_55 VDD:21 VDD:41 17.9166
R2_56 VDD:21 VDD:23 50.1665
R2_57 VDD:22 VDD:24 100.37
R2_58 VDD:22 VDD:34 12.4587
R2_59 VDD:22 VDD:42 34.3372
R2_60 VDD:23 VDD:24 31.764
R2_61 VDD:23 VDD:25 50.1665
R2_62 VDD:24 VDD:26 100.37
R2_63 VDD:24 VDD:35 12.4587
R2_64 VDD:25 VDD:26 31.764
R2_65 VDD:26 VDD:27 100.37
R2_66 VDD:26 VDD:36 12.4587
R2_67 VDD:27 VDD:29 100.37
R2_68 VDD:27 VDD:37 12.4587
R2_69 VDD:28 VDD:29 31.764
R2_70 VDD:28 VDD:30 50.1665
R2_71 VDD:29 VDD:31 100.37
R2_72 VDD:29 VDD:38 12.4587
R2_73 VDD:30 VDD:31 31.764
R2_74 VDD:30 VDD:32 50.1665
R2_75 VDD:31 VDD:33 100.37
R2_76 VDD:31 VDD:39 12.4587
R2_77 VDD:32 VDD:33 31.764
R2_78 VDD:32 VDD:58 17.9166
R2_79 VDD:33 VDD:40 12.4587
R2_80 VDD:33 VDD:43 34.3372
R2_81 VDD:34 VDD:44 7.8411
R2_82 VDD:35 VDD:46 7.84041
R2_83 VDD:36 VDD:48 7.84041
R2_84 VDD:37 VDD:50 7.84041
R2_85 VDD:38 VDD:52 7.84041
R2_86 VDD:39 VDD:54 7.84041
R2_87 VDD:40 VDD:56 7.8411

*|NET A 0.00010074PF
*|P (A B 0 0.0210 0.0720)
*|I (M1:GATE M1 GATE I 3.6e-19 0.5040 0.0360)
*|I (M10:GATE M10 GATE I 3.6e-19 0.1260 0.0360)
*|I (M11:GATE M11 GATE I 3.6e-19 0.0840 0.0360)
*|I (M12:GATE M12 GATE I 3.6e-19 0.0420 0.0360)
*|I (M13:GATE M13 GATE I 3.6e-19 0.5040 0.1080)
*|I (M14:GATE M14 GATE I 3.6e-19 0.4620 0.1080)
*|I (M15:GATE M15 GATE I 3.6e-19 0.4200 0.1080)
*|I (M16:GATE M16 GATE I 3.6e-19 0.3780 0.1080)
*|I (M17:GATE M17 GATE I 3.6e-19 0.3360 0.1080)
*|I (M18:GATE M18 GATE I 3.6e-19 0.2940 0.1080)
*|I (M19:GATE M19 GATE I 3.6e-19 0.2520 0.1080)
*|I (M2:GATE M2 GATE I 3.6e-19 0.4620 0.0360)
*|I (M20:GATE M20 GATE I 3.6e-19 0.2100 0.1080)
*|I (M21:GATE M21 GATE I 3.6e-19 0.1680 0.1080)
*|I (M22:GATE M22 GATE I 3.6e-19 0.1260 0.1080)
*|I (M23:GATE M23 GATE I 3.6e-19 0.0840 0.1080)
*|I (M24:GATE M24 GATE I 3.6e-19 0.0420 0.1080)
*|I (M3:GATE M3 GATE I 3.6e-19 0.4200 0.0360)
*|I (M4:GATE M4 GATE I 3.6e-19 0.3780 0.0360)
*|I (M5:GATE M5 GATE I 3.6e-19 0.3360 0.0360)
*|I (M6:GATE M6 GATE I 3.6e-19 0.2940 0.0360)
*|I (M7:GATE M7 GATE I 3.6e-19 0.2520 0.0360)
*|I (M8:GATE M8 GATE I 3.6e-19 0.2100 0.0360)
*|I (M9:GATE M9 GATE I 3.6e-19 0.1680 0.0360)
C3_1 A VSS:14 2.64712e-19
C3_2 A:76 VSS:19 1.23247e-18
C3_3 A VSS:27 9.50471e-20
C3_4 A:26 VSS:27 4.60642e-19
C3_5 A:27 VSS:27 7.89427e-21
C3_6 A:30 VSS:27 4.59524e-19
C3_7 A:31 VSS:27 7.89427e-21
C3_8 A:35 VSS:27 4.59524e-19
C3_9 A:36 VSS:27 7.89427e-21
C3_10 A:40 VSS:27 4.59524e-19
C3_11 A:41 VSS:27 7.89427e-21
C3_12 A:45 VSS:27 4.59524e-19
C3_13 A:46 VSS:27 7.89427e-21
C3_14 A:50 VSS:27 4.59524e-19
C3_15 A:51 VSS:27 7.89427e-21
C3_16 A:55 VSS:27 4.59524e-19
C3_17 A:56 VSS:27 7.89427e-21
C3_18 A:60 VSS:27 4.59524e-19
C3_19 A:61 VSS:27 7.89427e-21
C3_20 A:65 VSS:27 4.59524e-19
C3_21 A:66 VSS:27 7.89427e-21
C3_22 A:70 VSS:27 4.59524e-19
C3_23 A:71 VSS:27 7.89427e-21
C3_24 A:75 VSS:27 4.60197e-19
C3_25 A:76 VSS:27 7.89427e-21
C3_26 A:80 VSS:27 4.68614e-19
C3_27 A:81 VSS:27 7.89427e-21
C3_28 A:108 VSS:27 2.22114e-20
C3_29 A VSS:28 5.1458e-20
C3_30 A VSS:35 1.4195e-18
C3_31 A:26 VSS:35 2.2911e-20
C3_32 A:70 VSS:35 2.5889e-20
C3_33 A:75 VSS:35 4.22666e-20
C3_34 A:80 VSS:35 2.5889e-20
C3_35 A:108 VSS:35 2.73385e-18
C3_36 A:70 VSS:36 1.02173e-19
C3_37 A:76 VSS:36 6.91052e-19
C3_38 A:77 VSS:36 1.87735e-19
C3_39 A:80 VSS:36 1.94396e-20
C3_40 A:108 VSS:36 3.06792e-19
C3_41 A:108 VSS:37 3.06792e-19
C3_42 A:108 VSS:38 3.06792e-19
C3_43 A:108 VSS:39 3.06792e-19
C3_44 A:108 VSS:40 3.06792e-19
C3_45 A VSS:41 5.86331e-19
C3_46 A:108 VSS:41 2.46889e-19
C3_47 A:109 VDD:14 1.1494e-19
C3_48 A:78 VDD:19 1.23268e-18
C3_49 A:108 VDD:22 9.9272e-21
C3_50 A:109 VDD:22 4.82443e-19
C3_51 A:108 VDD:24 6.63905e-20
C3_52 A:108 VDD:26 6.63905e-20
C3_53 A:108 VDD:27 6.63905e-20
C3_54 A:108 VDD:29 6.63905e-20
C3_55 A:77 VDD:31 1.87735e-19
C3_56 A:78 VDD:31 6.91121e-19
C3_57 A:79 VDD:31 2.55697e-19
C3_58 A:84 VDD:31 3.93596e-22
C3_59 A:108 VDD:31 6.63905e-20
C3_60 A:29 VDD:33 1.14913e-19
C3_61 A:34 VDD:33 1.15217e-19
C3_62 A:39 VDD:33 1.15217e-19
C3_63 A:44 VDD:33 1.15217e-19
C3_64 A:49 VDD:33 1.15217e-19
C3_65 A:54 VDD:33 1.15217e-19
C3_66 A:59 VDD:33 1.15217e-19
C3_67 A:64 VDD:33 1.15217e-19
C3_68 A:69 VDD:33 1.15217e-19
C3_69 A:74 VDD:33 1.15217e-19
C3_70 A:79 VDD:33 1.15891e-19
C3_71 A:84 VDD:33 1.24307e-19
C3_72 A:109 VDD:34 1.33203e-19
C3_73 A:29 VDD:41 5.72243e-20
C3_74 A:34 VDD:41 4.17741e-20
C3_75 A:39 VDD:41 4.17741e-20
C3_76 A:44 VDD:41 4.17741e-20
C3_77 A:49 VDD:41 4.17741e-20
C3_78 A:54 VDD:41 4.17741e-20
C3_79 A:59 VDD:41 4.17741e-20
C3_80 A:64 VDD:41 4.17741e-20
C3_81 A:69 VDD:41 4.17741e-20
C3_82 A:74 VDD:41 4.17741e-20
C3_83 A:79 VDD:41 8.39806e-20
C3_84 A:84 VDD:41 6.76391e-20
C3_85 A:108 VDD:41 2.7385e-18
C3_86 A:109 VDD:41 1.42742e-18
Cg3_87 A VSS 2.25353e-18
Cg3_88 A:26 VSS 1.08842e-19
Cg3_89 A:28 VSS 3.4119e-19
Cg3_90 A:29 VSS 2.25021e-19
Cg3_91 A:30 VSS 1.09775e-19
Cg3_92 A:32 VSS 3.4119e-19
Cg3_93 A:34 VSS 2.27134e-19
Cg3_94 A:35 VSS 1.09775e-19
Cg3_95 A:37 VSS 3.4119e-19
Cg3_96 A:39 VSS 2.27134e-19
Cg3_97 A:40 VSS 1.09775e-19
Cg3_98 A:42 VSS 3.4119e-19
Cg3_99 A:44 VSS 2.27134e-19
Cg3_100 A:45 VSS 1.09775e-19
Cg3_101 A:47 VSS 3.4119e-19
Cg3_102 A:49 VSS 2.27134e-19
Cg3_103 A:50 VSS 1.09775e-19
Cg3_104 A:52 VSS 3.4119e-19
Cg3_105 A:54 VSS 2.27134e-19
Cg3_106 A:55 VSS 1.09775e-19
Cg3_107 A:57 VSS 3.4119e-19
Cg3_108 A:59 VSS 2.27134e-19
Cg3_109 A:60 VSS 1.09775e-19
Cg3_110 A:62 VSS 3.4119e-19
Cg3_111 A:64 VSS 2.27134e-19
Cg3_112 A:65 VSS 1.09775e-19
Cg3_113 A:67 VSS 3.4119e-19
Cg3_114 A:69 VSS 2.27134e-19
Cg3_115 A:70 VSS 2.08947e-19
Cg3_116 A:72 VSS 3.4119e-19
Cg3_117 A:74 VSS 2.27134e-19
Cg3_118 A:75 VSS 1.00471e-19
Cg3_119 A:77 VSS 5.60298e-19
Cg3_120 A:79 VSS 2.38246e-19
Cg3_121 A:80 VSS 9.99012e-20
Cg3_122 A:82 VSS 9.8281e-19
Cg3_123 A:84 VSS 2.37676e-19
Cg3_124 A:85 VSS 6.32666e-19
Cg3_125 A:87 VSS 7.88992e-20
Cg3_126 A:89 VSS 7.39304e-20
Cg3_127 A:91 VSS 7.39304e-20
Cg3_128 A:93 VSS 7.39304e-20
Cg3_129 A:95 VSS 7.39304e-20
Cg3_130 A:97 VSS 7.39304e-20
Cg3_131 A:99 VSS 7.39304e-20
Cg3_132 A:101 VSS 7.39304e-20
Cg3_133 A:103 VSS 7.39304e-20
Cg3_134 A:105 VSS 7.39304e-20
Cg3_135 A:108 VSS 8.11141e-18
Cg3_136 A:109 VSS 2.26157e-18
R3_1 A A:86 12.5416
R3_2 A A:109 29.4429
R3_3 A A:123 27.5916
R3_4 M1:GATE A:81 7.57576
R3_5 M1:GATE A:80 7.57576
R3_6 M10:GATE A:36 7.57576
R3_7 M10:GATE A:35 7.57576
R3_8 M11:GATE A:31 7.57576
R3_9 M11:GATE A:30 7.57576
R3_10 M12:GATE A:27 7.57576
R3_11 M12:GATE A:26 7.57576
R3_12 M13:GATE A:83 7.57576
R3_13 M13:GATE A:82 7.57576
R3_14 M14:GATE A:78 7.57576
R3_15 M14:GATE A:77 7.57576
R3_16 M15:GATE A:73 7.57576
R3_17 M15:GATE A:72 7.57576
R3_18 M16:GATE A:68 7.57576
R3_19 M16:GATE A:67 7.57576
R3_20 M17:GATE A:63 7.57576
R3_21 M17:GATE A:62 7.57576
R3_22 M18:GATE A:58 7.57576
R3_23 M18:GATE A:57 7.57576
R3_24 M19:GATE A:53 7.57576
R3_25 M19:GATE A:52 7.57576
R3_26 M2:GATE A:76 7.57576
R3_27 M2:GATE A:75 7.57576
R3_28 M20:GATE A:48 7.57576
R3_29 M20:GATE A:47 7.57576
R3_30 M21:GATE A:43 7.57576
R3_31 M21:GATE A:42 7.57576
R3_32 M22:GATE A:38 7.57576
R3_33 M22:GATE A:37 7.57576
R3_34 M23:GATE A:33 7.57576
R3_35 M23:GATE A:32 7.57576
R3_36 M24:GATE A:29 13.1313
R3_37 M24:GATE A:28 7.57576
R3_38 M3:GATE A:71 7.57576
R3_39 M3:GATE A:70 7.57576
R3_40 M4:GATE A:66 7.57576
R3_41 M4:GATE A:65 7.57576
R3_42 M5:GATE A:61 7.57576
R3_43 M5:GATE A:60 7.57576
R3_44 M6:GATE A:56 7.57576
R3_45 M6:GATE A:55 7.57576
R3_46 M7:GATE A:51 7.57576
R3_47 M7:GATE A:50 7.57576
R3_48 M8:GATE A:46 7.57576
R3_49 M8:GATE A:45 7.57576
R3_50 M9:GATE A:41 7.57576
R3_51 M9:GATE A:40 7.57576
R3_52 A:26 A:110 5.55556
R3_53 A:27 A:87 10.6061
R3_54 A:28 A:87 10.6061
R3_55 A:30 A:111 5.55556
R3_56 A:31 A:89 10.6061
R3_57 A:32 A:89 10.6061
R3_58 A:33 A:34 5.55556
R3_59 A:35 A:112 5.55556
R3_60 A:36 A:91 10.6061
R3_61 A:37 A:91 10.6061
R3_62 A:38 A:39 5.55556
R3_63 A:40 A:113 5.55556
R3_64 A:41 A:93 10.6061
R3_65 A:42 A:93 10.6061
R3_66 A:43 A:44 5.55556
R3_67 A:45 A:114 5.55556
R3_68 A:46 A:95 10.6061
R3_69 A:47 A:95 10.6061
R3_70 A:48 A:49 5.55556
R3_71 A:50 A:115 5.55556
R3_72 A:51 A:97 10.6061
R3_73 A:52 A:97 10.6061
R3_74 A:53 A:54 5.55556
R3_75 A:55 A:116 5.55556
R3_76 A:56 A:99 10.6061
R3_77 A:57 A:99 10.6061
R3_78 A:58 A:59 5.55556
R3_79 A:60 A:117 5.55556
R3_80 A:61 A:101 10.6061
R3_81 A:62 A:101 10.6061
R3_82 A:63 A:64 5.55556
R3_83 A:65 A:118 5.55556
R3_84 A:66 A:103 10.6061
R3_85 A:67 A:103 10.6061
R3_86 A:68 A:69 5.55556
R3_87 A:70 A:119 5.55556
R3_88 A:71 A:105 10.6061
R3_89 A:72 A:105 10.6061
R3_90 A:73 A:74 5.55556
R3_91 A:75 A:120 5.55556
R3_92 A:76 A:85 10.6061
R3_93 A:77 A:85 10.6061
R3_94 A:78 A:79 5.55556
R3_95 A:80 A:121 5.55556
R3_96 A:81 A:122 10.6061
R3_97 A:82 A:122 10.6061
R3_98 A:83 A:84 5.55556
R3_99 A:85 A:107 27.7339
R3_100 A:86 A:87 63.5281
R3_101 A:86 A:88 25.0832
R3_102 A:88 A:89 63.5281
R3_103 A:88 A:90 25.0832
R3_104 A:90 A:91 63.5281
R3_105 A:90 A:92 25.0832
R3_106 A:92 A:93 63.5281
R3_107 A:92 A:94 25.0832
R3_108 A:94 A:95 63.5281
R3_109 A:94 A:96 25.0832
R3_110 A:96 A:97 63.5281
R3_111 A:96 A:98 25.0832
R3_112 A:98 A:99 63.5281
R3_113 A:98 A:100 25.0832
R3_114 A:100 A:101 63.5281
R3_115 A:100 A:102 25.0832
R3_116 A:102 A:103 63.5281
R3_117 A:102 A:104 25.0832
R3_118 A:104 A:105 63.5281
R3_119 A:104 A:106 37.6249
R3_120 A:106 A:107 63.5281
R3_121 A:106 A:108 3.58332
R3_122 A:107 A:122 27.7339

*|NET Y 0.000196891PF
*|P (Y B 0 0.5250 0.0720)
*|I (M1:SRC M1 SRC B 0 0.4980 0.0360)
*|I (M10:DRN M10 DRN B 0 0.1320 0.0360)
*|I (M11:SRC M11 SRC B 0 0.0780 0.0360)
*|I (M12:DRN M12 DRN B 0 0.0480 0.0360)
*|I (M13:SRC M13 SRC B 0 0.4980 0.1080)
*|I (M14:DRN M14 DRN B 0 0.4680 0.1080)
*|I (M15:SRC M15 SRC B 0 0.4140 0.1080)
*|I (M16:DRN M16 DRN B 0 0.3840 0.1080)
*|I (M17:SRC M17 SRC B 0 0.3300 0.1080)
*|I (M18:DRN M18 DRN B 0 0.3000 0.1080)
*|I (M19:SRC M19 SRC B 0 0.2460 0.1080)
*|I (M2:DRN M2 DRN B 0 0.4680 0.0360)
*|I (M20:DRN M20 DRN B 0 0.2160 0.1080)
*|I (M21:SRC M21 SRC B 0 0.1620 0.1080)
*|I (M22:DRN M22 DRN B 0 0.1320 0.1080)
*|I (M23:SRC M23 SRC B 0 0.0780 0.1080)
*|I (M24:DRN M24 DRN B 0 0.0480 0.1080)
*|I (M3:SRC M3 SRC B 0 0.4140 0.0360)
*|I (M4:DRN M4 DRN B 0 0.3840 0.0360)
*|I (M5:SRC M5 SRC B 0 0.3300 0.0360)
*|I (M6:DRN M6 DRN B 0 0.3000 0.0360)
*|I (M7:SRC M7 SRC B 0 0.2460 0.0360)
*|I (M8:DRN M8 DRN B 0 0.2160 0.0360)
*|I (M9:SRC M9 SRC B 0 0.1620 0.0360)
C4_1 M12:DRN VSS:14 2.82443e-20
C4_2 Y:74 VSS:14 6.05689e-20
C4_3 M10:DRN VSS:15 3.18486e-20
C4_4 Y:74 VSS:15 2.14342e-19
C4_5 M8:DRN VSS:16 3.18486e-20
C4_6 Y:74 VSS:16 1.21141e-19
C4_7 M6:DRN VSS:17 3.18486e-20
C4_8 Y:74 VSS:17 1.69892e-19
C4_9 M4:DRN VSS:18 3.18486e-20
C4_10 Y:74 VSS:18 2.14342e-19
C4_11 M2:DRN VSS:19 3.18486e-20
C4_12 Y:74 VSS:19 2.14342e-19
C4_13 Y:74 VSS:20 2.9084e-19
C4_14 M10:DRN VSS:27 2.08949e-20
C4_15 M12:DRN VSS:27 2.09115e-20
C4_16 M2:DRN VSS:27 2.08949e-20
C4_17 M4:DRN VSS:27 2.08949e-20
C4_18 M6:DRN VSS:27 2.08949e-20
C4_19 M8:DRN VSS:27 2.08949e-20
C4_20 Y:26 VSS:27 2.32212e-18
C4_21 Y:28 VSS:27 2.31904e-18
C4_22 Y:30 VSS:27 2.31904e-18
C4_23 Y:32 VSS:27 2.31904e-18
C4_24 Y:34 VSS:27 2.31904e-18
C4_25 Y:36 VSS:27 2.31904e-18
C4_26 Y:74 VSS:27 2.44397e-18
C4_27 Y:75 VSS:27 1.42102e-19
C4_28 Y:26 VSS:29 2.80042e-20
C4_29 Y:38 VSS:29 3.18486e-20
C4_30 Y:74 VSS:29 4.90766e-20
C4_31 Y:28 VSS:30 2.80042e-20
C4_32 Y:40 VSS:30 3.18486e-20
C4_33 Y:74 VSS:30 5.26818e-20
C4_34 Y:30 VSS:31 2.80042e-20
C4_35 Y:42 VSS:31 3.18486e-20
C4_36 Y:74 VSS:31 5.26818e-20
C4_37 Y:32 VSS:32 2.80042e-20
C4_38 Y:44 VSS:32 3.18486e-20
C4_39 Y:74 VSS:32 5.07732e-20
C4_40 Y:34 VSS:33 3.37061e-20
C4_41 Y:46 VSS:33 3.18486e-20
C4_42 Y:74 VSS:33 4.27146e-20
C4_43 Y:36 VSS:34 4.41381e-20
C4_44 Y:48 VSS:34 3.18486e-20
C4_45 Y:74 VSS:34 6.37557e-20
C4_46 Y:26 VSS:35 1.46945e-19
C4_47 Y:28 VSS:35 1.07096e-19
C4_48 Y:30 VSS:35 6.87154e-20
C4_49 Y:32 VSS:35 1.48486e-19
C4_50 Y:34 VSS:35 1.10106e-19
C4_51 Y:36 VSS:35 7.17256e-20
C4_52 Y:74 VSS:35 3.16835e-17
C4_53 Y:75 VSS:35 3.64011e-20
C4_54 M2:DRN VSS:36 1.38606e-19
C4_55 Y:74 VSS:36 4.39667e-19
C4_56 M4:DRN VSS:37 2.80042e-20
C4_57 Y:74 VSS:37 3.55471e-19
C4_58 M6:DRN VSS:38 2.80042e-20
C4_59 Y:74 VSS:38 5.80986e-19
C4_60 M8:DRN VSS:39 2.80042e-20
C4_61 Y:74 VSS:39 8.45399e-19
C4_62 M10:DRN VSS:40 2.80042e-20
C4_63 Y:74 VSS:40 3.69309e-19
C4_64 M12:DRN VSS:41 2.13821e-20
C4_65 Y:74 VSS:41 6.53731e-20
C4_66 M24:DRN VDD:14 2.82443e-20
C4_67 Y:75 VDD:14 6.02467e-20
C4_68 M22:DRN VDD:15 3.18808e-20
C4_69 Y:75 VDD:15 2.14209e-19
C4_70 M20:DRN VDD:16 3.18808e-20
C4_71 Y:75 VDD:16 1.20943e-19
C4_72 M18:DRN VDD:17 3.18808e-20
C4_73 Y:75 VDD:17 1.69728e-19
C4_74 M16:DRN VDD:18 3.18808e-20
C4_75 Y:75 VDD:18 2.14209e-19
C4_76 M14:DRN VDD:19 3.18808e-20
C4_77 Y:75 VDD:19 2.14209e-19
C4_78 Y:74 VDD:20 1.85749e-19
C4_79 Y:75 VDD:20 1.06224e-19
C4_80 M24:DRN VDD:22 2.13821e-20
C4_81 Y:75 VDD:22 6.53731e-20
C4_82 M22:DRN VDD:24 2.80634e-20
C4_83 Y:75 VDD:24 3.69317e-19
C4_84 M20:DRN VDD:26 2.80634e-20
C4_85 Y:75 VDD:26 8.45431e-19
C4_86 M18:DRN VDD:27 2.80634e-20
C4_87 Y:75 VDD:27 5.81004e-19
C4_88 M16:DRN VDD:29 2.80634e-20
C4_89 Y:75 VDD:29 3.55478e-19
C4_90 M14:DRN VDD:31 4.95842e-20
C4_91 Y:75 VDD:31 4.21213e-19
C4_92 Y:27 VDD:33 1.19561e-18
C4_93 Y:29 VDD:33 1.19561e-18
C4_94 Y:31 VDD:33 1.19561e-18
C4_95 Y:33 VDD:33 1.19561e-18
C4_96 Y:35 VDD:33 1.19561e-18
C4_97 Y:37 VDD:33 1.19561e-18
C4_98 Y:74 VDD:33 2.1059e-19
C4_99 Y:75 VDD:33 3.60608e-19
C4_100 Y:27 VDD:35 2.80634e-20
C4_101 Y:39 VDD:35 3.18808e-20
C4_102 Y:75 VDD:35 4.90875e-20
C4_103 Y:29 VDD:36 2.80634e-20
C4_104 Y:41 VDD:36 3.18808e-20
C4_105 Y:75 VDD:36 5.26983e-20
C4_106 Y:31 VDD:37 2.80634e-20
C4_107 Y:43 VDD:37 3.18808e-20
C4_108 Y:75 VDD:37 5.26983e-20
C4_109 Y:33 VDD:38 2.80634e-20
C4_110 Y:45 VDD:38 3.18808e-20
C4_111 Y:75 VDD:38 5.07867e-20
C4_112 Y:35 VDD:39 2.80634e-20
C4_113 Y:47 VDD:39 3.18808e-20
C4_114 Y:75 VDD:39 4.27156e-20
C4_115 Y:37 VDD:40 4.41973e-20
C4_116 Y:49 VDD:40 3.18808e-20
C4_117 Y:74 VDD:40 2.28626e-20
C4_118 Y:75 VDD:40 4.10334e-20
C4_119 Y:27 VDD:41 2.60138e-19
C4_120 Y:29 VDD:41 2.20393e-19
C4_121 Y:31 VDD:41 1.8212e-19
C4_122 Y:33 VDD:41 2.61668e-19
C4_123 Y:35 VDD:41 2.23395e-19
C4_124 Y:37 VDD:41 1.85122e-19
C4_125 Y:74 VDD:41 1.11727e-19
C4_126 Y:75 VDD:41 3.17479e-17
C4_127 Y:74 A 1.06979e-18
C4_128 Y:74 A:30 2.92747e-20
C4_129 Y:74 A:31 6.67062e-20
C4_130 Y:75 A:33 6.67242e-20
C4_131 Y:75 A:34 2.03913e-20
C4_132 Y:74 A:35 2.82147e-20
C4_133 Y:74 A:36 6.1289e-20
C4_134 Y:75 A:38 6.13044e-20
C4_135 Y:75 A:39 1.9335e-20
C4_136 Y:74 A:40 2.82147e-20
C4_137 Y:74 A:41 6.1289e-20
C4_138 Y:75 A:43 6.13044e-20
C4_139 Y:75 A:44 1.9335e-20
C4_140 Y:74 A:45 2.98804e-20
C4_141 Y:74 A:46 6.98018e-20
C4_142 Y:75 A:48 6.98213e-20
C4_143 Y:75 A:49 2.09949e-20
C4_144 Y:74 A:50 2.82147e-20
C4_145 Y:74 A:51 6.1289e-20
C4_146 Y:75 A:53 6.13044e-20
C4_147 Y:75 A:54 1.9335e-20
C4_148 Y:74 A:55 2.82147e-20
C4_149 Y:74 A:56 6.1289e-20
C4_150 Y:75 A:58 6.13044e-20
C4_151 Y:75 A:59 1.9335e-20
C4_152 Y:74 A:60 3.04861e-20
C4_153 Y:74 A:61 7.28973e-20
C4_154 Y:75 A:63 7.29184e-20
C4_155 Y:75 A:64 2.15986e-20
C4_156 Y:74 A:65 2.82147e-20
C4_157 Y:74 A:66 6.1289e-20
C4_158 Y:75 A:68 6.13044e-20
C4_159 Y:75 A:69 1.9335e-20
C4_160 Y:74 A:70 9.96357e-21
C4_161 Y:34 A:71 6.91052e-19
C4_162 Y:46 A:71 1.23247e-18
C4_163 Y:74 A:71 6.31209e-20
C4_164 Y:34 A:72 1.87735e-19
C4_165 Y:35 A:72 1.87735e-19
C4_166 Y:74 A:72 7.31977e-20
C4_167 Y:75 A:72 3.54683e-20
C4_168 Y:75 A:73 4.75517e-20
C4_169 Y:75 A:74 1.9335e-20
C4_170 Y:74 A:76 5.53339e-20
C4_171 Y:74 A:77 1.16874e-19
C4_172 Y:75 A:77 7.32791e-20
C4_173 Y:75 A:78 5.65913e-20
C4_174 Y:75 A:79 3.14075e-20
C4_175 Y:36 A:80 1.82222e-19
C4_176 Y:36 A:81 6.85177e-19
C4_177 Y:48 A:81 1.22701e-18
C4_178 Y:74 A:81 1.89763e-19
C4_179 Y:36 A:82 1.83539e-19
C4_180 Y:37 A:82 1.83539e-19
C4_181 Y:74 A:82 2.47161e-19
C4_182 Y:37 A:83 6.85193e-19
C4_183 Y:49 A:83 1.22717e-18
C4_184 Y:74 A:83 1.31702e-19
C4_185 Y:75 A:83 5.88993e-20
C4_186 Y:37 A:84 1.82222e-19
C4_187 M14:DRN A:85 2.09115e-20
C4_188 Y:36 A:85 1.17406e-18
C4_189 Y:37 A:85 2.33954e-18
C4_190 Y:74 A:85 2.14361e-19
C4_191 Y:75 A:85 1.16953e-19
C4_192 Y:75 A:89 2.61448e-20
C4_193 Y:75 A:91 2.61448e-20
C4_194 Y:75 A:93 2.61448e-20
C4_195 Y:75 A:95 2.61448e-20
C4_196 Y:75 A:97 2.61448e-20
C4_197 Y:75 A:99 2.61448e-20
C4_198 Y:75 A:101 2.61448e-20
C4_199 Y:75 A:103 2.61448e-20
C4_200 Y:75 A:105 2.61448e-20
C4_201 Y:26 A:108 3.01207e-19
C4_202 Y:27 A:108 5.96672e-20
C4_203 Y:28 A:108 3.00258e-19
C4_204 Y:29 A:108 5.87215e-20
C4_205 Y:30 A:108 3.00258e-19
C4_206 Y:31 A:108 5.87215e-20
C4_207 Y:32 A:108 3.00258e-19
C4_208 Y:33 A:108 5.87215e-20
C4_209 Y:34 A:108 3.00258e-19
C4_210 Y:35 A:108 5.87215e-20
C4_211 Y:36 A:108 3.60309e-19
C4_212 Y:37 A:108 1.98023e-19
C4_213 Y:74 A:108 1.73837e-17
C4_214 Y:75 A:108 1.65048e-17
C4_215 Y:74 A:109 1.19605e-19
C4_216 Y:75 A:109 9.91864e-19
Cg4_217 Y:26 VSS 4.11852e-19
Cg4_218 Y:27 VSS 3.60318e-19
Cg4_219 Y:28 VSS 4.11852e-19
Cg4_220 Y:29 VSS 3.60318e-19
Cg4_221 Y:30 VSS 4.11852e-19
Cg4_222 Y:31 VSS 3.60318e-19
Cg4_223 Y:32 VSS 4.11852e-19
Cg4_224 Y:33 VSS 3.60318e-19
Cg4_225 Y:34 VSS 4.04337e-19
Cg4_226 Y:35 VSS 3.60318e-19
Cg4_227 Y:36 VSS 3.06377e-19
Cg4_228 Y:37 VSS 2.97398e-19
Cg4_229 Y:38 VSS 2.67377e-19
Cg4_230 Y:39 VSS 2.67634e-19
Cg4_231 Y:40 VSS 2.67377e-19
Cg4_232 Y:41 VSS 2.67634e-19
Cg4_233 Y:42 VSS 2.67377e-19
Cg4_234 Y:43 VSS 2.67634e-19
Cg4_235 Y:44 VSS 2.67377e-19
Cg4_236 Y:45 VSS 2.67634e-19
Cg4_237 Y:46 VSS 2.67377e-19
Cg4_238 Y:47 VSS 2.67634e-19
Cg4_239 Y:48 VSS 2.20595e-19
Cg4_240 Y:49 VSS 2.20434e-19
Cg4_241 Y:74 VSS 8.54857e-18
Cg4_242 Y:75 VSS 6.09396e-18
R4_1 Y Y:75 25.8596
R4_2 Y Y:74 25.7999
R4_3 M1:SRC Y:48 30000.0
R4_4 M1:SRC Y:86 20270.3
R4_5 M1:SRC Y:36 57692.3
R4_6 M1:SRC Y:71 30000.0
R4_7 M10:DRN Y:40 30000.0
R4_8 M10:DRN Y:78 20270.3
R4_9 M10:DRN Y:28 57692.3
R4_10 M10:DRN Y:55 30000.0
R4_11 M11:SRC Y:38 30000.0
R4_12 M11:SRC Y:76 20270.3
R4_13 M11:SRC Y:26 57692.3
R4_14 M11:SRC Y:51 30000.0
R4_15 M12:DRN Y:38 30000.0
R4_16 M12:DRN Y:76 20270.3
R4_17 M12:DRN Y:26 57692.3
R4_18 M12:DRN Y:51 30000.0
R4_19 M13:SRC Y:37 30000.0
R4_20 M13:SRC Y:87 20089.3
R4_21 M13:SRC Y:49 59210.5
R4_22 M13:SRC Y:73 30000.0
R4_23 M14:DRN Y:37 30000.0
R4_24 M14:DRN Y:87 20089.3
R4_25 M14:DRN Y:49 59210.5
R4_26 M14:DRN Y:73 30000.0
R4_27 M15:SRC Y:35 30000.0
R4_28 M15:SRC Y:85 20089.3
R4_29 M15:SRC Y:47 59210.5
R4_30 M15:SRC Y:69 30000.0
R4_31 M16:DRN Y:35 30000.0
R4_32 M16:DRN Y:85 20089.3
R4_33 M16:DRN Y:47 59210.5
R4_34 M16:DRN Y:69 30000.0
R4_35 M17:SRC Y:33 30000.0
R4_36 M17:SRC Y:83 20089.3
R4_37 M17:SRC Y:45 59210.5
R4_38 M17:SRC Y:65 30000.0
R4_39 M18:DRN Y:33 30000.0
R4_40 M18:DRN Y:83 20089.3
R4_41 M18:DRN Y:45 59210.5
R4_42 M18:DRN Y:65 30000.0
R4_43 M19:SRC Y:31 30000.0
R4_44 M19:SRC Y:81 20089.3
R4_45 M19:SRC Y:43 59210.5
R4_46 M19:SRC Y:61 30000.0
R4_47 M2:DRN Y:48 30000.0
R4_48 M2:DRN Y:86 20270.3
R4_49 M2:DRN Y:36 57692.3
R4_50 M2:DRN Y:71 30000.0
R4_51 M20:DRN Y:31 30000.0
R4_52 M20:DRN Y:81 20089.3
R4_53 M20:DRN Y:43 59210.5
R4_54 M20:DRN Y:61 30000.0
R4_55 M21:SRC Y:29 30000.0
R4_56 M21:SRC Y:79 20089.3
R4_57 M21:SRC Y:41 59210.5
R4_58 M21:SRC Y:57 30000.0
R4_59 M22:DRN Y:29 30000.0
R4_60 M22:DRN Y:79 20089.3
R4_61 M22:DRN Y:41 59210.5
R4_62 M22:DRN Y:57 30000.0
R4_63 M23:SRC Y:27 30000.0
R4_64 M23:SRC Y:77 20089.3
R4_65 M23:SRC Y:39 59210.5
R4_66 M23:SRC Y:53 30000.0
R4_67 M24:DRN Y:27 30000.0
R4_68 M24:DRN Y:77 20089.3
R4_69 M24:DRN Y:39 59210.5
R4_70 M24:DRN Y:53 30000.0
R4_71 M3:SRC Y:46 30000.0
R4_72 M3:SRC Y:84 20270.3
R4_73 M3:SRC Y:34 57692.3
R4_74 M3:SRC Y:67 30000.0
R4_75 M4:DRN Y:46 30000.0
R4_76 M4:DRN Y:84 20270.3
R4_77 M4:DRN Y:34 57692.3
R4_78 M4:DRN Y:67 30000.0
R4_79 M5:SRC Y:44 30000.0
R4_80 M5:SRC Y:82 20270.3
R4_81 M5:SRC Y:32 57692.3
R4_82 M5:SRC Y:63 30000.0
R4_83 M6:DRN Y:44 30000.0
R4_84 M6:DRN Y:82 20270.3
R4_85 M6:DRN Y:32 57692.3
R4_86 M6:DRN Y:63 30000.0
R4_87 M7:SRC Y:42 30000.0
R4_88 M7:SRC Y:80 20270.3
R4_89 M7:SRC Y:30 57692.3
R4_90 M7:SRC Y:59 30000.0
R4_91 M8:DRN Y:42 30000.0
R4_92 M8:DRN Y:80 20270.3
R4_93 M8:DRN Y:30 57692.3
R4_94 M8:DRN Y:59 30000.0
R4_95 M9:SRC Y:40 30000.0
R4_96 M9:SRC Y:78 20270.3
R4_97 M9:SRC Y:28 57692.3
R4_98 M9:SRC Y:55 30000.0
R4_99 Y:26 Y:51 5.51634
R4_100 Y:27 Y:77 8.62446
R4_101 Y:27 Y:53 14.1199
R4_102 Y:28 Y:55 5.51634
R4_103 Y:29 Y:57 14.1199
R4_104 Y:29 Y:79 8.62446
R4_105 Y:30 Y:59 5.51634
R4_106 Y:31 Y:61 14.1199
R4_107 Y:31 Y:81 8.62446
R4_108 Y:32 Y:63 5.51634
R4_109 Y:33 Y:65 14.1199
R4_110 Y:33 Y:83 8.62446
R4_111 Y:34 Y:67 5.51634
R4_112 Y:35 Y:69 14.1199
R4_113 Y:35 Y:85 8.62446
R4_114 Y:36 Y:71 5.51634
R4_115 Y:37 Y:73 14.1199
R4_116 Y:37 Y:87 8.62446
R4_117 Y:38 Y:51 14.0605
R4_118 Y:38 Y:76 49500.0
R4_119 Y:39 Y:53 5.45702
R4_120 Y:40 Y:55 14.0605
R4_121 Y:40 Y:78 49500.0
R4_122 Y:41 Y:57 5.45702
R4_123 Y:42 Y:59 14.0605
R4_124 Y:42 Y:80 49500.0
R4_125 Y:43 Y:61 5.45702
R4_126 Y:44 Y:63 14.0605
R4_127 Y:44 Y:82 49500.0
R4_128 Y:45 Y:65 5.45702
R4_129 Y:46 Y:67 14.0605
R4_130 Y:46 Y:84 49500.0
R4_131 Y:47 Y:69 5.45702
R4_132 Y:48 Y:71 14.0605
R4_133 Y:48 Y:86 49500.0
R4_134 Y:49 Y:73 5.45702
R4_135 Y:50 Y:51 63.5281
R4_136 Y:50 Y:88 3.58332
R4_137 Y:50 Y:54 50.1665
R4_138 Y:51 Y:76 3.7634
R4_139 Y:52 Y:53 63.5281
R4_140 Y:52 Y:89 3.58332
R4_141 Y:52 Y:56 50.1665
R4_142 Y:53 Y:77 21900.0
R4_143 Y:54 Y:55 63.5281
R4_144 Y:54 Y:58 50.1665
R4_145 Y:55 Y:78 3.7634
R4_146 Y:56 Y:57 63.5281
R4_147 Y:56 Y:60 50.1665
R4_148 Y:57 Y:79 21900.0
R4_149 Y:58 Y:59 63.5281
R4_150 Y:58 Y:62 50.1665
R4_151 Y:59 Y:80 3.7634
R4_152 Y:60 Y:61 63.5281
R4_153 Y:60 Y:64 50.1665
R4_154 Y:61 Y:81 21900.0
R4_155 Y:62 Y:63 63.5281
R4_156 Y:62 Y:66 50.1665
R4_157 Y:63 Y:82 3.7634
R4_158 Y:64 Y:65 63.5281
R4_159 Y:64 Y:68 50.1665
R4_160 Y:65 Y:83 21900.0
R4_161 Y:66 Y:67 63.5281
R4_162 Y:66 Y:70 50.1665
R4_163 Y:67 Y:84 3.7634
R4_164 Y:68 Y:69 63.5281
R4_165 Y:68 Y:72 50.1665
R4_166 Y:69 Y:85 21900.0
R4_167 Y:70 Y:71 63.5281
R4_168 Y:70 Y:74 25.0832
R4_169 Y:71 Y:86 3.7634
R4_170 Y:72 Y:73 63.5281
R4_171 Y:72 Y:75 25.0832
R4_172 Y:73 Y:87 21900.0

*|NET 6 0PF
R6_1 6:1 6:2 109455.0

*|NET 7 0.000125289PF
C7_1 7:1 VSS:14 8.03136e-19
C7_2 7:1 VSS:15 8.03382e-19
C7_3 7:1 VSS:16 8.03382e-19
C7_4 7:1 VSS:17 8.03382e-19
C7_5 7:1 VSS:18 8.03382e-19
C7_6 7:1 VSS:27 9.31172e-20
C7_7 7:3 VSS:27 1.35956e-19
C7_8 7:1 VSS:35 2.26853e-18
C7_9 7:2 VSS:35 5.66869e-19
C7_10 7:3 VSS:35 3.20198e-20
C7_11 7:1 VSS:37 1.50868e-18
C7_12 7:1 VSS:38 1.50868e-18
C7_13 7:1 VSS:39 1.50868e-18
C7_14 7:1 VSS:40 1.50868e-18
C7_15 7:1 VSS:41 1.50136e-18
C7_16 7:1 VDD:14 8.0314e-19
C7_17 7:1 VDD:15 8.03418e-19
C7_18 7:1 VDD:16 8.03418e-19
C7_19 7:1 VDD:17 8.03418e-19
C7_20 7:1 VDD:18 8.03418e-19
C7_21 7:1 VDD:22 1.50126e-18
C7_22 7:1 VDD:24 1.50862e-18
C7_23 7:1 VDD:26 1.50862e-18
C7_24 7:1 VDD:27 1.50862e-18
C7_25 7:1 VDD:29 1.50862e-18
C7_26 7:1 VDD:31 3.47913e-19
C7_27 7:1 VDD:41 2.94207e-18
C7_28 7:1 Y:26 1.07714e-18
C7_29 7:1 Y:27 1.07721e-18
C7_30 7:1 Y:28 1.07714e-18
C7_31 7:1 Y:29 1.07721e-18
C7_32 7:1 Y:30 1.07714e-18
C7_33 7:1 Y:31 1.07721e-18
C7_34 7:1 Y:32 1.07714e-18
C7_35 7:1 Y:33 1.07721e-18
C7_36 7:1 Y:34 1.0432e-20
C7_37 7:2 Y:34 1.80413e-19
C7_38 7:1 Y:35 8.89477e-19
C7_39 7:1 Y:38 8.03382e-19
C7_40 7:1 Y:39 8.03418e-19
C7_41 7:1 Y:40 8.03382e-19
C7_42 7:1 Y:41 8.03418e-19
C7_43 7:1 Y:42 8.03382e-19
C7_44 7:1 Y:43 8.03418e-19
C7_45 7:1 Y:44 8.03382e-19
C7_46 7:1 Y:45 8.03418e-19
C7_47 7:1 Y:47 8.03418e-19
C7_48 7:1 Y:74 2.80216e-18
C7_49 7:2 Y:74 1.71771e-19
C7_50 7:3 Y:74 1.55906e-19
C7_51 7:1 Y:75 2.58906e-18
Cg7_52 7:1 VSS 6.79562e-17
Cg7_53 7:2 VSS 3.96707e-18
R7_1 7:1 7:2 10289.6
R7_2 7:2 7:3 1326.22

*|NET _generated_10 5.37479e-06PF
C8_1 _generated_10:1 VSS:27 9.21148e-19
C8_2 _generated_10:1 VSS:35 9.68154e-20
C8_3 _generated_10:1 A:77 7.90108e-21
C8_4 _generated_10:1 A:80 1.58022e-21
C8_5 _generated_10:1 A:82 2.39886e-19
Cg8_6 _generated_10:1 VSS 3.50331e-18
R8_1 _generated_10:1 _generated_10:2 28.2828

*|NET _generated_11 5.0073e-06PF
C9_1 _generated_11:1 VDD:33 5.78695e-19
C9_2 _generated_11:1 VDD:41 1.91825e-19
C9_3 _generated_11:1 A:77 7.90108e-21
C9_4 _generated_11:1 A:82 2.39886e-19
C9_5 _generated_11:1 A:84 1.58022e-21
C9_6 _generated_11:1 _generated_10:1 6.0415e-19
Cg9_7 _generated_11:1 VSS 3.38326e-18
R9_1 _generated_11:1 _generated_11:2 28.2828

*|NET _generated_8 2.86348e-06PF
C10_1 _generated_8:1 VSS:35 2.25577e-20
C10_2 _generated_8:1 VSS:41 3.44976e-19
C10_3 _generated_8:1 A 3.06042e-19
C10_4 _generated_8:1 7:1 6.61239e-19
Cg10_5 _generated_8:1 VSS 9.49624e-19
R10_1 _generated_8:1 _generated_8:2 28.2828

*|NET _generated_9 3.08088e-06PF
C11_1 _generated_9:1 VSS:27 1.47021e-19
C11_2 _generated_9:1 VDD:22 3.74453e-19
C11_3 _generated_9:1 VDD:33 1.18927e-19
C11_4 _generated_9:1 VDD:41 4.89892e-20
C11_5 _generated_9:1 A:109 3.15962e-19
C11_6 _generated_9:1 7:1 5.65589e-19
C11_7 _generated_9:1 _generated_8:1 5.79044e-19
Cg11_8 _generated_9:1 VSS 9.3089e-19
R11_1 _generated_9:1 _generated_9:2 28.2828

*
* Instance Section
*
MM1 M1:DRN M1:GATE M1:SRC VSS NMOS_LVT l=0.012u w=0.03u NF=1
MM10 M10:DRN M10:GATE M10:SRC VSS NMOS_LVT l=0.012u w=0.03u NF=1
MM11 M11:DRN M11:GATE M11:SRC VSS NMOS_LVT l=0.012u w=0.03u NF=1
MM12 M12:DRN M12:GATE M12:SRC VSS NMOS_LVT l=0.012u w=0.03u NF=1
MM13 M13:DRN M13:GATE M13:SRC VDD PMOS_LVT l=0.012u w=0.03u NF=1
MM14 M14:DRN M14:GATE M14:SRC VDD PMOS_LVT l=0.012u w=0.03u NF=1
MM15 M15:DRN M15:GATE M15:SRC VDD PMOS_LVT l=0.012u w=0.03u NF=1
MM16 M16:DRN M16:GATE M16:SRC VDD PMOS_LVT l=0.012u w=0.03u NF=1
MM17 M17:DRN M17:GATE M17:SRC VDD PMOS_LVT l=0.012u w=0.03u NF=1
MM18 M18:DRN M18:GATE M18:SRC VDD PMOS_LVT l=0.012u w=0.03u NF=1
MM19 M19:DRN M19:GATE M19:SRC VDD PMOS_LVT l=0.012u w=0.03u NF=1
MM2 M2:DRN M2:GATE M2:SRC VSS NMOS_LVT l=0.012u w=0.03u NF=1
MM20 M20:DRN M20:GATE M20:SRC VDD PMOS_LVT l=0.012u w=0.03u NF=1
MM21 M21:DRN M21:GATE M21:SRC VDD PMOS_LVT l=0.012u w=0.03u NF=1
MM22 M22:DRN M22:GATE M22:SRC VDD PMOS_LVT l=0.012u w=0.03u NF=1
MM23 M23:DRN M23:GATE M23:SRC VDD PMOS_LVT l=0.012u w=0.03u NF=1
MM24 M24:DRN M24:GATE M24:SRC VDD PMOS_LVT l=0.012u w=0.03u NF=1
MM3 M3:DRN M3:GATE M3:SRC VSS NMOS_LVT l=0.012u w=0.03u NF=1
MM4 M4:DRN M4:GATE M4:SRC VSS NMOS_LVT l=0.012u w=0.03u NF=1
MM5 M5:DRN M5:GATE M5:SRC VSS NMOS_LVT l=0.012u w=0.03u NF=1
MM6 M6:DRN M6:GATE M6:SRC VSS NMOS_LVT l=0.012u w=0.03u NF=1
MM7 M7:DRN M7:GATE M7:SRC VSS NMOS_LVT l=0.012u w=0.03u NF=1
MM8 M8:DRN M8:GATE M8:SRC VSS NMOS_LVT l=0.012u w=0.03u NF=1
MM9 M9:DRN M9:GATE M9:SRC VSS NMOS_LVT l=0.012u w=0.03u NF=1

.ENDS
