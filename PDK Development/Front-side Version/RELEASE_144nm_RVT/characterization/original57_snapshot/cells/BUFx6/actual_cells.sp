*
*|DSPF 1.3
*|DESIGN BUFx6
*|DATE "Tue Nov  3 20:52:44 2026"
*|VENDOR "Synopsys"
*|PROGRAM "StarRC"
*|VERSION "X-2025.06-SP1"
*|DIVIDER /
*|DELIMITER :
**FORMAT SPF
*

** COMMENTS

** OPERATING_TEMPERATURE 25
** GLOBAL_TEMPERATURE 25
**
** TCAD_GRD_FILE /cedar/cedar_coe/ece-limsk/yhuang861/GRO/.planning/experiments_migrated_20261022/usc144_github_release_20261103/sources/github_FSPR.nxtgrd
**   TCAD_TIME_STAMP Tue Mar 31 05:07:55 2026
**   TCADGRD_VERSION 89

.SUBCKT BUFx6 VSS VDD A Y

*|GROUND_NET VSS

*|NET VSS 0.000112734PF
*|P (VSS B 0 0.2100 0.0000)
*|I (M1:DRN M1 DRN B 0 0.5100 0.0360)
*|I (M10:SRC M10 SRC B 0 0.1200 0.0360)
*|I (M11:DRN M11 DRN B 0 0.0900 0.0360)
*|I (M12:SRC M12 SRC B 0 0.0360 0.0360)
*|I (M2:SRC M2 SRC B 0 0.4560 0.0360)
*|I (M3:DRN M3 DRN B 0 0.4260 0.0360)
*|I (M4:SRC M4 SRC B 0 0.3720 0.0360)
*|I (M5:DRN M5 DRN B 0 0.3420 0.0360)
*|I (M6:SRC M6 SRC B 0 0.2880 0.0360)
*|I (M7:DRN M7 DRN B 0 0.2580 0.0360)
*|I (M8:SRC M8 SRC B 0 0.2040 0.0360)
*|I (M9:DRN M9 DRN B 0 0.1740 0.0360)
Cg1_1 VSS:14 VSS 2.68769e-19
Cg1_2 VSS:15 VSS 2.77026e-19
Cg1_3 VSS:16 VSS 2.77026e-19
Cg1_4 VSS:17 VSS 2.68769e-19
Cg1_5 VSS:18 VSS 2.77026e-19
Cg1_6 VSS:19 VSS 2.77026e-19
Cg1_7 VSS:20 VSS 1.78742e-19
Cg1_8 VSS:28 VSS 4.41114e-18
Cg1_9 VSS:36 VSS 1.48289e-17
Cg1_10 VSS:37 VSS 6.21352e-19
Cg1_11 VSS:38 VSS 5.30645e-19
Cg1_12 VSS:39 VSS 4.84738e-19
Cg1_13 VSS:40 VSS 4.61252e-19
Cg1_14 VSS:41 VSS 5.27661e-19
Cg1_15 VSS:42 VSS 4.90549e-19
R1_1 VSS VSS:24 37.6249
R1_2 VSS VSS:23 12.5416
R1_3 M1:DRN VSS:35 30000.0
R1_4 M1:DRN VSS:20 30000.0
R1_5 M1:DRN VSS:57 15000.0
R1_6 M10:SRC VSS:30 30000.0
R1_7 M10:SRC VSS:15 30000.0
R1_8 M10:SRC VSS:47 15000.0
R1_9 M11:DRN VSS:30 30000.0
R1_10 M11:DRN VSS:15 30000.0
R1_11 M11:DRN VSS:47 15000.0
R1_12 M12:SRC VSS:29 30000.0
R1_13 M12:SRC VSS:14 30000.0
R1_14 M12:SRC VSS:45 15000.0
R1_15 M2:SRC VSS:34 30000.0
R1_16 M2:SRC VSS:19 30000.0
R1_17 M2:SRC VSS:55 15000.0
R1_18 M3:DRN VSS:34 30000.0
R1_19 M3:DRN VSS:19 30000.0
R1_20 M3:DRN VSS:55 15000.0
R1_21 M4:SRC VSS:33 30000.0
R1_22 M4:SRC VSS:18 30000.0
R1_23 M4:SRC VSS:53 15000.0
R1_24 M5:DRN VSS:33 30000.0
R1_25 M5:DRN VSS:18 30000.0
R1_26 M5:DRN VSS:53 15000.0
R1_27 M6:SRC VSS:32 30000.0
R1_28 M6:SRC VSS:17 30000.0
R1_29 M6:SRC VSS:51 15000.0
R1_30 M7:DRN VSS:32 30000.0
R1_31 M7:DRN VSS:17 30000.0
R1_32 M7:DRN VSS:51 15000.0
R1_33 M8:SRC VSS:31 30000.0
R1_34 M8:SRC VSS:16 30000.0
R1_35 M8:SRC VSS:49 15000.0
R1_36 M9:DRN VSS:31 30000.0
R1_37 M9:DRN VSS:16 30000.0
R1_38 M9:DRN VSS:49 15000.0
R1_39 VSS:14 VSS:45 7.8411
R1_40 VSS:14 VSS:42 12.4587
R1_41 VSS:15 VSS:47 7.84041
R1_42 VSS:15 VSS:41 12.4587
R1_43 VSS:16 VSS:49 7.84041
R1_44 VSS:16 VSS:40 12.4587
R1_45 VSS:17 VSS:51 7.84041
R1_46 VSS:17 VSS:39 12.4587
R1_47 VSS:18 VSS:53 7.84041
R1_48 VSS:18 VSS:38 12.4587
R1_49 VSS:19 VSS:55 7.84041
R1_50 VSS:19 VSS:37 12.4587
R1_51 VSS:20 VSS:57 7.8411
R1_52 VSS:20 VSS:28 12.4587
R1_53 VSS:21 VSS:36 17.9166
R1_54 VSS:21 VSS:22 50.1665
R1_55 VSS:21 VSS:42 31.764
R1_56 VSS:22 VSS:23 50.1665
R1_57 VSS:22 VSS:41 31.764
R1_58 VSS:23 VSS:40 31.764
R1_59 VSS:24 VSS:25 50.1665
R1_60 VSS:24 VSS:39 31.764
R1_61 VSS:25 VSS:26 50.1665
R1_62 VSS:25 VSS:38 31.764
R1_63 VSS:26 VSS:27 50.1665
R1_64 VSS:26 VSS:37 31.764
R1_65 VSS:27 VSS:28 31.764
R1_66 VSS:27 VSS:59 17.9166
R1_67 VSS:28 VSS:37 100.37
R1_68 VSS:28 VSS:44 34.3372
R1_69 VSS:29 VSS:45 7.8411
R1_70 VSS:29 VSS:46 1.77981
R1_71 VSS:30 VSS:47 7.84041
R1_72 VSS:30 VSS:48 1.77981
R1_73 VSS:31 VSS:49 7.84041
R1_74 VSS:31 VSS:50 1.77981
R1_75 VSS:32 VSS:51 7.84041
R1_76 VSS:32 VSS:52 1.77981
R1_77 VSS:33 VSS:53 7.84041
R1_78 VSS:33 VSS:54 1.77981
R1_79 VSS:34 VSS:55 7.84041
R1_80 VSS:34 VSS:56 1.77981
R1_81 VSS:35 VSS:57 7.8411
R1_82 VSS:35 VSS:58 1.77981
R1_83 VSS:37 VSS:38 100.37
R1_84 VSS:38 VSS:39 100.37
R1_85 VSS:39 VSS:40 100.37
R1_86 VSS:40 VSS:41 100.37
R1_87 VSS:41 VSS:42 100.37
R1_88 VSS:42 VSS:43 34.3372

*|NET VDD 0.00012265PF
*|P (VDD B 0 0.2100 0.1440)
*|I (M13:DRN M13 DRN B 0 0.5100 0.1080)
*|I (M14:SRC M14 SRC B 0 0.4560 0.1080)
*|I (M15:DRN M15 DRN B 0 0.4260 0.1080)
*|I (M16:SRC M16 SRC B 0 0.3720 0.1080)
*|I (M17:DRN M17 DRN B 0 0.3420 0.1080)
*|I (M18:SRC M18 SRC B 0 0.2880 0.1080)
*|I (M19:DRN M19 DRN B 0 0.2580 0.1080)
*|I (M20:SRC M20 SRC B 0 0.2040 0.1080)
*|I (M21:DRN M21 DRN B 0 0.1740 0.1080)
*|I (M22:SRC M22 SRC B 0 0.1200 0.1080)
*|I (M23:DRN M23 DRN B 0 0.0900 0.1080)
*|I (M24:SRC M24 SRC B 0 0.0360 0.1080)
C2_1 VDD:22 VSS:28 6.39187e-20
C2_2 VDD:34 VSS:28 4.19119e-19
C2_3 VDD:35 VSS:28 6.70033e-21
C2_4 VDD:41 VSS:28 2.00992e-20
C2_5 VDD:42 VSS:28 7.79004e-20
C2_6 VDD:34 VSS:36 2.76282e-20
C2_7 VDD:42 VSS:36 5.95297e-19
C2_8 VDD:32 VSS:37 4.65622e-19
C2_9 VDD:40 VSS:37 2.24891e-20
C2_10 VDD:30 VSS:38 4.65622e-19
C2_11 VDD:39 VSS:38 2.24891e-20
C2_12 VDD:28 VSS:39 4.49535e-19
C2_13 VDD:38 VSS:39 2.26115e-20
C2_14 VDD:26 VSS:40 4.65622e-19
C2_15 VDD:37 VSS:40 2.24891e-20
C2_16 VDD:24 VSS:41 4.65622e-19
C2_17 VDD:36 VSS:41 2.24891e-20
C2_18 VDD:22 VSS:42 4.49535e-19
C2_19 VDD:35 VSS:42 2.26115e-20
Cg2_20 VDD:14 VSS 2.68918e-19
Cg2_21 VDD:15 VSS 2.77231e-19
Cg2_22 VDD:16 VSS 2.77231e-19
Cg2_23 VDD:17 VSS 2.68918e-19
Cg2_24 VDD:18 VSS 2.77231e-19
Cg2_25 VDD:19 VSS 2.77231e-19
Cg2_26 VDD:20 VSS 1.78742e-19
Cg2_27 VDD:22 VSS 8.09005e-19
Cg2_28 VDD:24 VSS 8.39321e-19
Cg2_29 VDD:26 VSS 7.72908e-19
Cg2_30 VDD:28 VSS 8.06371e-19
Cg2_31 VDD:30 VSS 8.42306e-19
Cg2_32 VDD:32 VSS 8.14855e-19
Cg2_33 VDD:34 VSS 2.62777e-17
Cg2_34 VDD:35 VSS 5.43919e-21
Cg2_35 VDD:42 VSS 1.47981e-17
R2_1 VDD VDD:27 37.6249
R2_2 VDD VDD:25 12.5416
R2_3 M13:DRN VDD:41 30000.0
R2_4 M13:DRN VDD:20 30000.0
R2_5 M13:DRN VDD:57 15000.0
R2_6 M14:SRC VDD:40 30000.0
R2_7 M14:SRC VDD:19 30000.0
R2_8 M14:SRC VDD:55 15000.0
R2_9 M15:DRN VDD:40 30000.0
R2_10 M15:DRN VDD:19 30000.0
R2_11 M15:DRN VDD:55 15000.0
R2_12 M16:SRC VDD:39 30000.0
R2_13 M16:SRC VDD:18 30000.0
R2_14 M16:SRC VDD:53 15000.0
R2_15 M17:DRN VDD:39 30000.0
R2_16 M17:DRN VDD:18 30000.0
R2_17 M17:DRN VDD:53 15000.0
R2_18 M18:SRC VDD:38 30000.0
R2_19 M18:SRC VDD:17 30000.0
R2_20 M18:SRC VDD:51 15000.0
R2_21 M19:DRN VDD:38 30000.0
R2_22 M19:DRN VDD:17 30000.0
R2_23 M19:DRN VDD:51 15000.0
R2_24 M20:SRC VDD:37 30000.0
R2_25 M20:SRC VDD:16 30000.0
R2_26 M20:SRC VDD:49 15000.0
R2_27 M21:DRN VDD:37 30000.0
R2_28 M21:DRN VDD:16 30000.0
R2_29 M21:DRN VDD:49 15000.0
R2_30 M22:SRC VDD:36 30000.0
R2_31 M22:SRC VDD:15 30000.0
R2_32 M22:SRC VDD:47 15000.0
R2_33 M23:DRN VDD:36 30000.0
R2_34 M23:DRN VDD:15 30000.0
R2_35 M23:DRN VDD:47 15000.0
R2_36 M24:SRC VDD:35 30000.0
R2_37 M24:SRC VDD:14 30000.0
R2_38 M24:SRC VDD:45 15000.0
R2_39 VDD:14 VDD:45 7.8411
R2_40 VDD:14 VDD:46 1.77981
R2_41 VDD:15 VDD:47 7.84041
R2_42 VDD:15 VDD:48 1.77981
R2_43 VDD:16 VDD:49 7.84041
R2_44 VDD:16 VDD:50 1.77981
R2_45 VDD:17 VDD:51 7.84041
R2_46 VDD:17 VDD:52 1.77981
R2_47 VDD:18 VDD:53 7.84041
R2_48 VDD:18 VDD:54 1.77981
R2_49 VDD:19 VDD:55 7.84041
R2_50 VDD:19 VDD:56 1.77981
R2_51 VDD:20 VDD:57 7.8411
R2_52 VDD:20 VDD:58 1.77981
R2_53 VDD:21 VDD:22 31.764
R2_54 VDD:21 VDD:42 17.9166
R2_55 VDD:21 VDD:23 50.1665
R2_56 VDD:22 VDD:24 100.37
R2_57 VDD:22 VDD:35 12.4587
R2_58 VDD:22 VDD:43 34.3372
R2_59 VDD:23 VDD:24 31.764
R2_60 VDD:23 VDD:25 50.1665
R2_61 VDD:24 VDD:26 100.37
R2_62 VDD:24 VDD:36 12.4587
R2_63 VDD:25 VDD:26 31.764
R2_64 VDD:26 VDD:28 100.37
R2_65 VDD:26 VDD:37 12.4587
R2_66 VDD:27 VDD:28 31.764
R2_67 VDD:27 VDD:29 50.1665
R2_68 VDD:28 VDD:30 100.37
R2_69 VDD:28 VDD:38 12.4587
R2_70 VDD:29 VDD:30 31.764
R2_71 VDD:29 VDD:31 50.1665
R2_72 VDD:30 VDD:32 100.37
R2_73 VDD:30 VDD:39 12.4587
R2_74 VDD:31 VDD:32 31.764
R2_75 VDD:31 VDD:33 50.1665
R2_76 VDD:32 VDD:34 100.37
R2_77 VDD:32 VDD:40 12.4587
R2_78 VDD:33 VDD:34 31.764
R2_79 VDD:33 VDD:59 17.9166
R2_80 VDD:34 VDD:41 12.4587
R2_81 VDD:34 VDD:44 34.3372
R2_82 VDD:35 VDD:45 7.8411
R2_83 VDD:36 VDD:47 7.84041
R2_84 VDD:37 VDD:49 7.84041
R2_85 VDD:38 VDD:51 7.84041
R2_86 VDD:39 VDD:53 7.84041
R2_87 VDD:40 VDD:55 7.84041
R2_88 VDD:41 VDD:57 7.8411

*|NET A 4.9202e-05PF
*|P (A B 0 0.0210 0.0720)
*|I (M10:GATE M10 GATE I 3.6e-19 0.1260 0.0360)
*|I (M11:GATE M11 GATE I 3.6e-19 0.0840 0.0360)
*|I (M12:GATE M12 GATE I 3.6e-19 0.0420 0.0360)
*|I (M19:GATE M19 GATE I 3.6e-19 0.2520 0.1080)
*|I (M20:GATE M20 GATE I 3.6e-19 0.2100 0.1080)
*|I (M21:GATE M21 GATE I 3.6e-19 0.1680 0.1080)
*|I (M22:GATE M22 GATE I 3.6e-19 0.1260 0.1080)
*|I (M23:GATE M23 GATE I 3.6e-19 0.0840 0.1080)
*|I (M24:GATE M24 GATE I 3.6e-19 0.0420 0.1080)
*|I (M7:GATE M7 GATE I 3.6e-19 0.2520 0.0360)
*|I (M8:GATE M8 GATE I 3.6e-19 0.2100 0.0360)
*|I (M9:GATE M9 GATE I 3.6e-19 0.1680 0.0360)
C3_1 A VSS:14 2.63049e-19
C3_2 A VSS:28 9.50471e-20
C3_3 A:14 VSS:28 4.60642e-19
C3_4 A:15 VSS:28 7.89427e-21
C3_5 A:18 VSS:28 4.59524e-19
C3_6 A:19 VSS:28 7.89427e-21
C3_7 A:23 VSS:28 4.59524e-19
C3_8 A:24 VSS:28 7.89427e-21
C3_9 A:28 VSS:28 4.59524e-19
C3_10 A:29 VSS:28 7.89427e-21
C3_11 A:33 VSS:28 4.59524e-19
C3_12 A:34 VSS:28 7.89427e-21
C3_13 A:38 VSS:28 4.59524e-19
C3_14 A:39 VSS:28 7.89427e-21
C3_15 A:54 VSS:28 2.22114e-20
C3_16 A VSS:29 5.11548e-20
C3_17 A VSS:36 1.4195e-18
C3_18 A:14 VSS:36 2.2911e-20
C3_19 A:54 VSS:36 1.47814e-18
C3_20 A:54 VSS:40 3.06792e-19
C3_21 A:54 VSS:41 3.06792e-19
C3_22 A VSS:42 5.82752e-19
C3_23 A:54 VSS:42 2.44474e-19
C3_24 A:55 VDD:14 1.1494e-19
C3_25 A:54 VDD:22 9.9272e-21
C3_26 A:55 VDD:22 4.8205e-19
C3_27 A:54 VDD:24 6.63905e-20
C3_28 A:54 VDD:26 6.63905e-20
C3_29 A:17 VDD:34 1.14913e-19
C3_30 A:22 VDD:34 1.15217e-19
C3_31 A:27 VDD:34 1.15217e-19
C3_32 A:32 VDD:34 1.15217e-19
C3_33 A:37 VDD:34 1.15217e-19
C3_34 A:42 VDD:34 1.15217e-19
C3_35 A:55 VDD:35 1.31726e-19
C3_36 A:17 VDD:42 5.72243e-20
C3_37 A:22 VDD:42 4.17741e-20
C3_38 A:27 VDD:42 4.17741e-20
C3_39 A:32 VDD:42 4.17741e-20
C3_40 A:37 VDD:42 4.17741e-20
C3_41 A:42 VDD:42 4.17741e-20
C3_42 A:54 VDD:42 1.47814e-18
C3_43 A:55 VDD:42 1.42742e-18
Cg3_44 A VSS 2.23183e-18
Cg3_45 A:14 VSS 1.08842e-19
Cg3_46 A:16 VSS 3.4119e-19
Cg3_47 A:17 VSS 2.25021e-19
Cg3_48 A:18 VSS 1.09775e-19
Cg3_49 A:20 VSS 3.4119e-19
Cg3_50 A:22 VSS 2.27134e-19
Cg3_51 A:23 VSS 1.09775e-19
Cg3_52 A:25 VSS 3.4119e-19
Cg3_53 A:27 VSS 2.27134e-19
Cg3_54 A:28 VSS 1.09775e-19
Cg3_55 A:30 VSS 3.4119e-19
Cg3_56 A:32 VSS 2.27134e-19
Cg3_57 A:33 VSS 1.09775e-19
Cg3_58 A:35 VSS 3.4119e-19
Cg3_59 A:37 VSS 2.27134e-19
Cg3_60 A:38 VSS 1.09775e-19
Cg3_61 A:40 VSS 3.4119e-19
Cg3_62 A:42 VSS 2.27134e-19
Cg3_63 A:43 VSS 3.24935e-19
Cg3_64 A:45 VSS 7.88992e-20
Cg3_65 A:47 VSS 7.39304e-20
Cg3_66 A:49 VSS 7.39304e-20
Cg3_67 A:51 VSS 7.39304e-20
Cg3_68 A:54 VSS 3.98598e-18
Cg3_69 A:55 VSS 2.23903e-18
R3_1 A A:55 29.4429
R3_2 A A:63 27.5916
R3_3 A A:44 12.5416
R3_4 M10:GATE A:24 7.57576
R3_5 M10:GATE A:23 7.57576
R3_6 M11:GATE A:19 7.57576
R3_7 M11:GATE A:18 7.57576
R3_8 M12:GATE A:15 7.57576
R3_9 M12:GATE A:14 7.57576
R3_10 M19:GATE A:41 7.57576
R3_11 M19:GATE A:40 7.57576
R3_12 M20:GATE A:36 7.57576
R3_13 M20:GATE A:35 7.57576
R3_14 M21:GATE A:31 7.57576
R3_15 M21:GATE A:30 7.57576
R3_16 M22:GATE A:26 7.57576
R3_17 M22:GATE A:25 7.57576
R3_18 M23:GATE A:21 7.57576
R3_19 M23:GATE A:20 7.57576
R3_20 M24:GATE A:17 13.1313
R3_21 M24:GATE A:16 7.57576
R3_22 M7:GATE A:39 7.57576
R3_23 M7:GATE A:38 7.57576
R3_24 M8:GATE A:34 7.57576
R3_25 M8:GATE A:33 7.57576
R3_26 M9:GATE A:29 7.57576
R3_27 M9:GATE A:28 7.57576
R3_28 A:14 A:56 5.55556
R3_29 A:15 A:45 10.6061
R3_30 A:16 A:45 10.6061
R3_31 A:18 A:57 5.55556
R3_32 A:19 A:47 10.6061
R3_33 A:20 A:47 10.6061
R3_34 A:21 A:22 5.55556
R3_35 A:23 A:58 5.55556
R3_36 A:24 A:49 10.6061
R3_37 A:25 A:49 10.6061
R3_38 A:26 A:27 5.55556
R3_39 A:28 A:59 5.55556
R3_40 A:29 A:51 10.6061
R3_41 A:30 A:51 10.6061
R3_42 A:31 A:32 5.55556
R3_43 A:33 A:60 5.55556
R3_44 A:34 A:43 10.6061
R3_45 A:35 A:43 10.6061
R3_46 A:36 A:37 5.55556
R3_47 A:38 A:61 5.55556
R3_48 A:39 A:62 10.6061
R3_49 A:40 A:62 10.6061
R3_50 A:41 A:42 5.55556
R3_51 A:43 A:53 27.7339
R3_52 A:44 A:45 63.5281
R3_53 A:44 A:46 25.0832
R3_54 A:46 A:47 63.5281
R3_55 A:46 A:48 25.0832
R3_56 A:48 A:49 63.5281
R3_57 A:48 A:50 25.0832
R3_58 A:50 A:51 63.5281
R3_59 A:50 A:52 37.6249
R3_60 A:52 A:53 63.5281
R3_61 A:52 A:54 3.58332
R3_62 A:53 A:62 27.7339

*|NET Y 0.000101484PF
*|P (Y B 0 0.5250 0.0720)
*|I (M1:SRC M1 SRC B 0 0.4980 0.0360)
*|I (M13:SRC M13 SRC B 0 0.4980 0.1080)
*|I (M14:DRN M14 DRN B 0 0.4680 0.1080)
*|I (M15:SRC M15 SRC B 0 0.4140 0.1080)
*|I (M16:DRN M16 DRN B 0 0.3840 0.1080)
*|I (M17:SRC M17 SRC B 0 0.3300 0.1080)
*|I (M18:DRN M18 DRN B 0 0.3000 0.1080)
*|I (M2:DRN M2 DRN B 0 0.4680 0.0360)
*|I (M3:SRC M3 SRC B 0 0.4140 0.0360)
*|I (M4:DRN M4 DRN B 0 0.3840 0.0360)
*|I (M5:SRC M5 SRC B 0 0.3300 0.0360)
*|I (M6:DRN M6 DRN B 0 0.3000 0.0360)
C4_1 M6:DRN VSS:17 2.82443e-20
C4_2 Y:38 VSS:17 6.05689e-20
C4_3 M4:DRN VSS:18 3.18486e-20
C4_4 Y:38 VSS:18 2.14342e-19
C4_5 M2:DRN VSS:19 3.18486e-20
C4_6 Y:38 VSS:19 2.14342e-19
C4_7 Y:38 VSS:20 2.88434e-19
C4_8 M2:DRN VSS:28 2.08949e-20
C4_9 M4:DRN VSS:28 2.08949e-20
C4_10 M6:DRN VSS:28 2.09115e-20
C4_11 Y:14 VSS:28 2.32212e-18
C4_12 Y:16 VSS:28 2.31904e-18
C4_13 Y:18 VSS:28 2.31904e-18
C4_14 Y:38 VSS:28 1.6226e-18
C4_15 Y:39 VSS:28 1.40654e-19
C4_16 Y:14 VSS:33 2.80042e-20
C4_17 Y:20 VSS:33 3.18486e-20
C4_18 Y:38 VSS:33 5.07732e-20
C4_19 Y:16 VSS:34 3.37061e-20
C4_20 Y:22 VSS:34 3.18486e-20
C4_21 Y:38 VSS:34 4.27146e-20
C4_22 Y:18 VSS:35 4.41381e-20
C4_23 Y:24 VSS:35 3.18486e-20
C4_24 Y:38 VSS:35 6.37557e-20
C4_25 Y:14 VSS:36 1.49956e-19
C4_26 Y:16 VSS:36 1.10106e-19
C4_27 Y:18 VSS:36 7.17256e-20
C4_28 Y:38 VSS:36 1.52726e-17
C4_29 Y:39 VSS:36 3.64011e-20
C4_30 M2:DRN VSS:37 1.38606e-19
C4_31 Y:38 VSS:37 4.39667e-19
C4_32 M4:DRN VSS:38 2.80042e-20
C4_33 Y:38 VSS:38 3.55471e-19
C4_34 M6:DRN VSS:39 2.13821e-20
C4_35 Y:38 VSS:39 6.53731e-20
C4_36 M18:DRN VDD:17 2.82443e-20
C4_37 Y:39 VDD:17 6.02467e-20
C4_38 M16:DRN VDD:18 3.18808e-20
C4_39 Y:39 VDD:18 2.14209e-19
C4_40 M14:DRN VDD:19 3.18808e-20
C4_41 Y:39 VDD:19 2.14209e-19
C4_42 Y:38 VDD:20 1.83328e-19
C4_43 Y:39 VDD:20 1.06224e-19
C4_44 M18:DRN VDD:28 2.13821e-20
C4_45 Y:39 VDD:28 6.53731e-20
C4_46 M16:DRN VDD:30 2.80634e-20
C4_47 Y:39 VDD:30 3.55478e-19
C4_48 M14:DRN VDD:32 4.95842e-20
C4_49 Y:39 VDD:32 4.21213e-19
C4_50 Y:15 VDD:34 1.19561e-18
C4_51 Y:17 VDD:34 1.19561e-18
C4_52 Y:19 VDD:34 1.19561e-18
C4_53 Y:38 VDD:34 2.10235e-19
C4_54 Y:39 VDD:34 3.60608e-19
C4_55 Y:15 VDD:39 2.80634e-20
C4_56 Y:21 VDD:39 3.18808e-20
C4_57 Y:39 VDD:39 5.07867e-20
C4_58 Y:17 VDD:40 2.80634e-20
C4_59 Y:23 VDD:40 3.18808e-20
C4_60 Y:39 VDD:40 4.27156e-20
C4_61 Y:19 VDD:41 4.41973e-20
C4_62 Y:25 VDD:41 3.18808e-20
C4_63 Y:38 VDD:41 2.28626e-20
C4_64 Y:39 VDD:41 4.10334e-20
C4_65 Y:15 VDD:42 2.63139e-19
C4_66 Y:17 VDD:42 2.23395e-19
C4_67 Y:19 VDD:42 1.85122e-19
C4_68 Y:38 VDD:42 1.11727e-19
C4_69 Y:39 VDD:42 1.52497e-17
Cg4_70 Y:14 VSS 4.11852e-19
Cg4_71 Y:15 VSS 3.60318e-19
Cg4_72 Y:16 VSS 4.04337e-19
Cg4_73 Y:17 VSS 3.60318e-19
Cg4_74 Y:18 VSS 3.06377e-19
Cg4_75 Y:19 VSS 2.97398e-19
Cg4_76 Y:20 VSS 2.67377e-19
Cg4_77 Y:21 VSS 2.67634e-19
Cg4_78 Y:22 VSS 2.67377e-19
Cg4_79 Y:23 VSS 2.67634e-19
Cg4_80 Y:24 VSS 2.20595e-19
Cg4_81 Y:25 VSS 2.20434e-19
Cg4_82 Y:38 VSS 5.68797e-18
Cg4_83 Y:39 VSS 3.25702e-18
R4_1 Y Y:39 25.8596
R4_2 Y Y:38 25.7999
R4_3 M1:SRC Y:24 30000.0
R4_4 M1:SRC Y:44 20270.3
R4_5 M1:SRC Y:18 57692.3
R4_6 M1:SRC Y:35 30000.0
R4_7 M13:SRC Y:19 30000.0
R4_8 M13:SRC Y:45 20089.3
R4_9 M13:SRC Y:25 59210.5
R4_10 M13:SRC Y:37 30000.0
R4_11 M14:DRN Y:19 30000.0
R4_12 M14:DRN Y:45 20089.3
R4_13 M14:DRN Y:25 59210.5
R4_14 M14:DRN Y:37 30000.0
R4_15 M15:SRC Y:17 30000.0
R4_16 M15:SRC Y:43 20089.3
R4_17 M15:SRC Y:23 59210.5
R4_18 M15:SRC Y:33 30000.0
R4_19 M16:DRN Y:17 30000.0
R4_20 M16:DRN Y:43 20089.3
R4_21 M16:DRN Y:23 59210.5
R4_22 M16:DRN Y:33 30000.0
R4_23 M17:SRC Y:15 30000.0
R4_24 M17:SRC Y:41 20089.3
R4_25 M17:SRC Y:21 59210.5
R4_26 M17:SRC Y:29 30000.0
R4_27 M18:DRN Y:15 30000.0
R4_28 M18:DRN Y:41 20089.3
R4_29 M18:DRN Y:21 59210.5
R4_30 M18:DRN Y:29 30000.0
R4_31 M2:DRN Y:24 30000.0
R4_32 M2:DRN Y:44 20270.3
R4_33 M2:DRN Y:18 57692.3
R4_34 M2:DRN Y:35 30000.0
R4_35 M3:SRC Y:22 30000.0
R4_36 M3:SRC Y:42 20270.3
R4_37 M3:SRC Y:16 57692.3
R4_38 M3:SRC Y:31 30000.0
R4_39 M4:DRN Y:22 30000.0
R4_40 M4:DRN Y:42 20270.3
R4_41 M4:DRN Y:16 57692.3
R4_42 M4:DRN Y:31 30000.0
R4_43 M5:SRC Y:20 30000.0
R4_44 M5:SRC Y:40 20270.3
R4_45 M5:SRC Y:14 57692.3
R4_46 M5:SRC Y:27 30000.0
R4_47 M6:DRN Y:20 30000.0
R4_48 M6:DRN Y:40 20270.3
R4_49 M6:DRN Y:14 57692.3
R4_50 M6:DRN Y:27 30000.0
R4_51 Y:14 Y:27 5.51634
R4_52 Y:15 Y:29 14.1199
R4_53 Y:15 Y:41 8.62446
R4_54 Y:16 Y:31 5.51634
R4_55 Y:17 Y:33 14.1199
R4_56 Y:17 Y:43 8.62446
R4_57 Y:18 Y:35 5.51634
R4_58 Y:19 Y:37 14.1199
R4_59 Y:19 Y:45 8.62446
R4_60 Y:20 Y:27 14.0605
R4_61 Y:20 Y:40 49500.0
R4_62 Y:21 Y:29 5.45702
R4_63 Y:22 Y:31 14.0605
R4_64 Y:22 Y:42 49500.0
R4_65 Y:23 Y:33 5.45702
R4_66 Y:24 Y:35 14.0605
R4_67 Y:24 Y:44 49500.0
R4_68 Y:25 Y:37 5.45702
R4_69 Y:26 Y:27 63.5281
R4_70 Y:26 Y:46 3.58332
R4_71 Y:26 Y:30 50.1665
R4_72 Y:27 Y:40 3.7634
R4_73 Y:28 Y:29 63.5281
R4_74 Y:28 Y:47 3.58332
R4_75 Y:28 Y:32 50.1665
R4_76 Y:29 Y:41 21900.0
R4_77 Y:30 Y:31 63.5281
R4_78 Y:30 Y:34 50.1665
R4_79 Y:31 Y:42 3.7634
R4_80 Y:32 Y:33 63.5281
R4_81 Y:32 Y:36 50.1665
R4_82 Y:33 Y:43 21900.0
R4_83 Y:34 Y:35 63.5281
R4_84 Y:34 Y:38 25.0832
R4_85 Y:35 Y:44 3.7634
R4_86 Y:36 Y:37 63.5281
R4_87 Y:36 Y:39 25.0832
R4_88 Y:37 Y:45 21900.0

*|NET 6 0.000151238PF
*|I (M1:GATE M1 GATE I 3.6e-19 0.5040 0.0360)
*|I (M10:DRN M10 DRN B 0 0.1320 0.0360)
*|I (M11:SRC M11 SRC B 0 0.0780 0.0360)
*|I (M12:DRN M12 DRN B 0 0.0480 0.0360)
*|I (M13:GATE M13 GATE I 3.6e-19 0.5040 0.1080)
*|I (M14:GATE M14 GATE I 3.6e-19 0.4620 0.1080)
*|I (M15:GATE M15 GATE I 3.6e-19 0.4200 0.1080)
*|I (M16:GATE M16 GATE I 3.6e-19 0.3780 0.1080)
*|I (M17:GATE M17 GATE I 3.6e-19 0.3360 0.1080)
*|I (M18:GATE M18 GATE I 3.6e-19 0.2940 0.1080)
*|I (M19:SRC M19 SRC B 0 0.2460 0.1080)
*|I (M2:GATE M2 GATE I 3.6e-19 0.4620 0.0360)
*|I (M20:DRN M20 DRN B 0 0.2160 0.1080)
*|I (M21:SRC M21 SRC B 0 0.1620 0.1080)
*|I (M22:DRN M22 DRN B 0 0.1320 0.1080)
*|I (M23:SRC M23 SRC B 0 0.0780 0.1080)
*|I (M24:DRN M24 DRN B 0 0.0480 0.1080)
*|I (M3:GATE M3 GATE I 3.6e-19 0.4200 0.0360)
*|I (M4:GATE M4 GATE I 3.6e-19 0.3780 0.0360)
*|I (M5:GATE M5 GATE I 3.6e-19 0.3360 0.0360)
*|I (M6:GATE M6 GATE I 3.6e-19 0.2940 0.0360)
*|I (M7:SRC M7 SRC B 0 0.2460 0.0360)
*|I (M8:DRN M8 DRN B 0 0.2160 0.0360)
*|I (M9:SRC M9 SRC B 0 0.1620 0.0360)
C6_1 M12:DRN VSS:14 2.82443e-20
C6_2 6:89 VSS:14 6.05689e-20
C6_3 M10:DRN VSS:15 3.18486e-20
C6_4 6:89 VSS:15 2.14342e-19
C6_5 M8:DRN VSS:16 3.18486e-20
C6_6 6:89 VSS:16 1.21141e-19
C6_7 6:89 VSS:17 1.09564e-19
C6_8 6:91 VSS:17 1.95068e-19
C6_9 6:45 VSS:19 1.23247e-18
C6_10 M10:DRN VSS:28 2.08949e-20
C6_11 M12:DRN VSS:28 2.09115e-20
C6_12 M8:DRN VSS:28 2.08949e-20
C6_13 6:25 VSS:28 4.60642e-19
C6_14 6:26 VSS:28 7.89427e-21
C6_15 6:29 VSS:28 4.59524e-19
C6_16 6:30 VSS:28 7.89427e-21
C6_17 6:34 VSS:28 4.59524e-19
C6_18 6:35 VSS:28 7.89427e-21
C6_19 6:39 VSS:28 4.59524e-19
C6_20 6:40 VSS:28 7.89427e-21
C6_21 6:44 VSS:28 4.60197e-19
C6_22 6:45 VSS:28 7.89427e-21
C6_23 6:49 VSS:28 4.68614e-19
C6_24 6:50 VSS:28 7.89427e-21
C6_25 6:54 VSS:28 2.32212e-18
C6_26 6:56 VSS:28 2.31904e-18
C6_27 6:58 VSS:28 2.31904e-18
C6_28 6:89 VSS:28 7.55628e-19
C6_29 6:92 VSS:28 2.22114e-20
C6_30 6:54 VSS:30 2.80042e-20
C6_31 6:61 VSS:30 3.18486e-20
C6_32 6:89 VSS:30 4.90766e-20
C6_33 6:56 VSS:31 2.80042e-20
C6_34 6:63 VSS:31 3.18486e-20
C6_35 6:89 VSS:31 5.26818e-20
C6_36 6:58 VSS:32 2.80042e-20
C6_37 6:65 VSS:32 3.18486e-20
C6_38 6:89 VSS:32 3.21953e-20
C6_39 6:91 VSS:32 2.27223e-20
C6_40 6:25 VSS:36 2.2911e-20
C6_41 6:39 VSS:36 2.5889e-20
C6_42 6:44 VSS:36 4.22666e-20
C6_43 6:49 VSS:36 2.5889e-20
C6_44 6:54 VSS:36 1.46945e-19
C6_45 6:56 VSS:36 1.07096e-19
C6_46 6:58 VSS:36 6.87154e-20
C6_47 6:89 VSS:36 1.50986e-17
C6_48 6:90 VSS:36 3.39022e-20
C6_49 6:91 VSS:36 7.69575e-20
C6_50 6:92 VSS:36 1.38475e-18
C6_51 6:39 VSS:37 1.02173e-19
C6_52 6:45 VSS:37 6.91052e-19
C6_53 6:46 VSS:37 1.87735e-19
C6_54 6:49 VSS:37 1.94396e-20
C6_55 6:92 VSS:37 3.06792e-19
C6_56 6:92 VSS:38 3.06792e-19
C6_57 6:89 VSS:39 3.48416e-19
C6_58 6:91 VSS:39 3.9844e-19
C6_59 6:92 VSS:39 2.44474e-19
C6_60 M8:DRN VSS:40 2.80042e-20
C6_61 6:89 VSS:40 8.45399e-19
C6_62 M10:DRN VSS:41 2.80042e-20
C6_63 6:89 VSS:41 3.69309e-19
C6_64 M12:DRN VSS:42 2.13821e-20
C6_65 6:89 VSS:42 6.53731e-20
C6_66 M24:DRN VDD:14 2.82443e-20
C6_67 6:90 VDD:14 6.02467e-20
C6_68 M22:DRN VDD:15 3.18808e-20
C6_69 6:90 VDD:15 2.14209e-19
C6_70 M20:DRN VDD:16 3.18808e-20
C6_71 6:90 VDD:16 1.20943e-19
C6_72 6:90 VDD:17 1.09556e-19
C6_73 6:91 VDD:17 1.96369e-19
C6_74 6:47 VDD:19 1.23268e-18
C6_75 M24:DRN VDD:22 2.13821e-20
C6_76 6:90 VDD:22 6.53731e-20
C6_77 M22:DRN VDD:24 2.80634e-20
C6_78 6:90 VDD:24 3.69317e-19
C6_79 M20:DRN VDD:26 2.80634e-20
C6_80 6:90 VDD:26 8.45431e-19
C6_81 6:90 VDD:28 3.47888e-19
C6_82 6:91 VDD:28 2.08636e-19
C6_83 6:92 VDD:28 9.9272e-21
C6_84 6:92 VDD:30 6.63905e-20
C6_85 6:46 VDD:32 1.87735e-19
C6_86 6:47 VDD:32 6.91121e-19
C6_87 6:48 VDD:32 2.55697e-19
C6_88 6:53 VDD:32 3.93596e-22
C6_89 6:92 VDD:32 6.63905e-20
C6_90 6:28 VDD:34 1.14913e-19
C6_91 6:33 VDD:34 1.15217e-19
C6_92 6:38 VDD:34 1.15217e-19
C6_93 6:43 VDD:34 1.15217e-19
C6_94 6:48 VDD:34 1.15891e-19
C6_95 6:53 VDD:34 1.24307e-19
C6_96 6:55 VDD:34 1.19561e-18
C6_97 6:57 VDD:34 1.19561e-18
C6_98 6:59 VDD:34 1.19561e-18
C6_99 6:55 VDD:36 2.80634e-20
C6_100 6:62 VDD:36 3.18808e-20
C6_101 6:90 VDD:36 4.90875e-20
C6_102 6:57 VDD:37 2.80634e-20
C6_103 6:64 VDD:37 3.18808e-20
C6_104 6:90 VDD:37 5.26983e-20
C6_105 6:59 VDD:38 2.80634e-20
C6_106 6:66 VDD:38 3.18808e-20
C6_107 6:90 VDD:38 3.21953e-20
C6_108 6:91 VDD:38 2.28626e-20
C6_109 6:28 VDD:42 5.72243e-20
C6_110 6:33 VDD:42 4.17741e-20
C6_111 6:38 VDD:42 4.17741e-20
C6_112 6:43 VDD:42 4.17741e-20
C6_113 6:48 VDD:42 8.39806e-20
C6_114 6:53 VDD:42 6.76391e-20
C6_115 6:55 VDD:42 2.60138e-19
C6_116 6:57 VDD:42 2.20393e-19
C6_117 6:59 VDD:42 1.8212e-19
C6_118 6:89 VDD:42 3.39334e-20
C6_119 6:90 VDD:42 1.51788e-17
C6_120 6:91 VDD:42 7.70993e-20
C6_121 6:92 VDD:42 1.3894e-18
C6_122 6:89 A 9.52493e-19
C6_123 6:91 A 1.5775e-19
C6_124 6:89 A:18 2.92747e-20
C6_125 6:89 A:19 6.67062e-20
C6_126 6:90 A:21 6.67242e-20
C6_127 6:90 A:22 2.03913e-20
C6_128 6:89 A:23 2.82147e-20
C6_129 6:89 A:24 6.1289e-20
C6_130 6:90 A:26 6.13044e-20
C6_131 6:90 A:27 1.9335e-20
C6_132 6:89 A:28 2.82147e-20
C6_133 6:89 A:29 6.1289e-20
C6_134 6:90 A:31 6.13044e-20
C6_135 6:90 A:32 1.9335e-20
C6_136 6:89 A:33 2.98804e-20
C6_137 6:89 A:34 6.98018e-20
C6_138 6:90 A:36 6.98213e-20
C6_139 6:90 A:37 2.09949e-20
C6_140 6:89 A:38 2.82147e-20
C6_141 6:89 A:39 7.384e-20
C6_142 6:90 A:41 7.38289e-20
C6_143 6:90 A:42 1.9335e-20
C6_144 M20:DRN A:43 2.09115e-20
C6_145 6:58 A:43 1.17406e-18
C6_146 6:59 A:43 2.33954e-18
C6_147 6:90 A:43 1.16953e-19
C6_148 6:92 A:43 1.85173e-19
C6_149 6:90 A:47 2.61448e-20
C6_150 6:90 A:49 2.61448e-20
C6_151 6:90 A:51 2.61448e-20
C6_152 6:54 A:54 3.01207e-19
C6_153 6:55 A:54 5.96672e-20
C6_154 6:56 A:54 3.00258e-19
C6_155 6:57 A:54 5.87215e-20
C6_156 6:58 A:54 2.13474e-19
C6_157 6:59 A:54 5.08919e-20
C6_158 6:89 A:54 7.1391e-18
C6_159 6:90 A:54 7.1195e-18
C6_160 6:91 A:54 2.37363e-19
C6_161 6:92 A:54 5.32038e-19
C6_162 6:90 A:55 9.89316e-19
C6_163 6:91 A:55 1.63521e-19
C6_164 6:60 M14:DRN 2.09115e-20
C6_165 6:92 Y:14 3.01207e-19
C6_166 6:92 Y:15 5.96672e-20
C6_167 6:40 Y:16 6.91052e-19
C6_168 6:41 Y:16 1.87735e-19
C6_169 6:92 Y:16 3.00258e-19
C6_170 6:41 Y:17 1.87735e-19
C6_171 6:92 Y:17 5.87215e-20
C6_172 6:49 Y:18 1.82222e-19
C6_173 6:50 Y:18 6.85177e-19
C6_174 6:51 Y:18 1.83539e-19
C6_175 6:60 Y:18 1.17406e-18
C6_176 6:92 Y:18 3.60309e-19
C6_177 6:51 Y:19 1.83539e-19
C6_178 6:52 Y:19 6.85193e-19
C6_179 6:53 Y:19 1.82222e-19
C6_180 6:60 Y:19 2.33954e-18
C6_181 6:92 Y:19 1.98023e-19
C6_182 6:40 Y:22 1.23247e-18
C6_183 6:50 Y:24 1.22701e-18
C6_184 6:52 Y:25 1.22717e-18
C6_185 6:29 Y:38 3.04861e-20
C6_186 6:30 Y:38 7.28973e-20
C6_187 6:34 Y:38 2.82147e-20
C6_188 6:35 Y:38 6.1289e-20
C6_189 6:39 Y:38 9.96357e-21
C6_190 6:40 Y:38 6.31209e-20
C6_191 6:41 Y:38 7.31977e-20
C6_192 6:45 Y:38 5.53339e-20
C6_193 6:46 Y:38 1.16874e-19
C6_194 6:50 Y:38 1.85881e-19
C6_195 6:51 Y:38 2.44609e-19
C6_196 6:52 Y:38 1.27796e-19
C6_197 6:60 Y:38 2.14361e-19
C6_198 6:89 Y:38 1.07856e-18
C6_199 6:91 Y:38 4.12628e-19
C6_200 6:92 Y:38 7.93938e-18
C6_201 6:32 Y:39 7.29184e-20
C6_202 6:33 Y:39 2.15986e-20
C6_203 6:37 Y:39 6.13044e-20
C6_204 6:38 Y:39 1.9335e-20
C6_205 6:41 Y:39 3.54683e-20
C6_206 6:42 Y:39 4.75517e-20
C6_207 6:43 Y:39 1.9335e-20
C6_208 6:46 Y:39 7.32791e-20
C6_209 6:47 Y:39 5.65913e-20
C6_210 6:48 Y:39 3.14075e-20
C6_211 6:52 Y:39 5.88993e-20
C6_212 6:60 Y:39 1.16953e-19
C6_213 6:70 Y:39 2.61448e-20
C6_214 6:72 Y:39 2.61448e-20
C6_215 6:74 Y:39 2.61448e-20
C6_216 6:90 Y:39 1.07856e-18
C6_217 6:91 Y:39 1.07722e-19
C6_218 6:92 Y:39 7.08755e-18
Cg6_219 6:25 VSS 1.08842e-19
Cg6_220 6:27 VSS 3.4119e-19
Cg6_221 6:28 VSS 2.25021e-19
Cg6_222 6:29 VSS 1.09775e-19
Cg6_223 6:31 VSS 3.4119e-19
Cg6_224 6:33 VSS 2.27134e-19
Cg6_225 6:34 VSS 1.09775e-19
Cg6_226 6:36 VSS 3.4119e-19
Cg6_227 6:38 VSS 2.27134e-19
Cg6_228 6:39 VSS 2.08947e-19
Cg6_229 6:41 VSS 3.4119e-19
Cg6_230 6:43 VSS 2.27134e-19
Cg6_231 6:44 VSS 1.00471e-19
Cg6_232 6:46 VSS 5.60298e-19
Cg6_233 6:48 VSS 2.38246e-19
Cg6_234 6:49 VSS 9.99012e-20
Cg6_235 6:51 VSS 9.8281e-19
Cg6_236 6:53 VSS 2.37676e-19
Cg6_237 6:54 VSS 4.11852e-19
Cg6_238 6:55 VSS 3.60318e-19
Cg6_239 6:56 VSS 4.11852e-19
Cg6_240 6:57 VSS 3.60318e-19
Cg6_241 6:58 VSS 3.06377e-19
Cg6_242 6:59 VSS 2.97398e-19
Cg6_243 6:60 VSS 6.27253e-19
Cg6_244 6:61 VSS 2.67377e-19
Cg6_245 6:62 VSS 2.67634e-19
Cg6_246 6:63 VSS 2.67377e-19
Cg6_247 6:64 VSS 2.67634e-19
Cg6_248 6:65 VSS 2.20595e-19
Cg6_249 6:66 VSS 2.20434e-19
Cg6_250 6:68 VSS 7.88992e-20
Cg6_251 6:70 VSS 7.39304e-20
Cg6_252 6:72 VSS 7.39304e-20
Cg6_253 6:74 VSS 7.39304e-20
Cg6_254 6:89 VSS 2.81937e-18
Cg6_255 6:90 VSS 2.81937e-18
Cg6_256 6:91 VSS 1.47353e-18
Cg6_257 6:92 VSS 3.00347e-18
R6_1 M1:GATE 6:50 7.57576
R6_2 M1:GATE 6:49 7.57576
R6_3 M10:DRN 6:63 30000.0
R6_4 M10:DRN 6:102 20270.3
R6_5 M10:DRN 6:56 57692.3
R6_6 M10:DRN 6:82 30000.0
R6_7 M11:SRC 6:61 30000.0
R6_8 M11:SRC 6:100 20270.3
R6_9 M11:SRC 6:54 57692.3
R6_10 M11:SRC 6:78 30000.0
R6_11 M12:DRN 6:61 30000.0
R6_12 M12:DRN 6:100 20270.3
R6_13 M12:DRN 6:54 57692.3
R6_14 M12:DRN 6:78 30000.0
R6_15 M13:GATE 6:52 7.57576
R6_16 M13:GATE 6:51 7.57576
R6_17 M14:GATE 6:47 7.57576
R6_18 M14:GATE 6:46 7.57576
R6_19 M15:GATE 6:42 7.57576
R6_20 M15:GATE 6:41 7.57576
R6_21 M16:GATE 6:37 7.57576
R6_22 M16:GATE 6:36 7.57576
R6_23 M17:GATE 6:32 7.57576
R6_24 M17:GATE 6:31 7.57576
R6_25 M18:GATE 6:28 13.1313
R6_26 M18:GATE 6:27 7.57576
R6_27 M19:SRC 6:59 30000.0
R6_28 M19:SRC 6:105 20089.3
R6_29 M19:SRC 6:66 59210.5
R6_30 M19:SRC 6:88 30000.0
R6_31 M2:GATE 6:45 7.57576
R6_32 M2:GATE 6:44 7.57576
R6_33 M20:DRN 6:59 30000.0
R6_34 M20:DRN 6:105 20089.3
R6_35 M20:DRN 6:66 59210.5
R6_36 M20:DRN 6:88 30000.0
R6_37 M21:SRC 6:57 30000.0
R6_38 M21:SRC 6:103 20089.3
R6_39 M21:SRC 6:64 59210.5
R6_40 M21:SRC 6:84 30000.0
R6_41 M22:DRN 6:57 30000.0
R6_42 M22:DRN 6:103 20089.3
R6_43 M22:DRN 6:64 59210.5
R6_44 M22:DRN 6:84 30000.0
R6_45 M23:SRC 6:55 30000.0
R6_46 M23:SRC 6:101 20089.3
R6_47 M23:SRC 6:62 59210.5
R6_48 M23:SRC 6:80 30000.0
R6_49 M24:DRN 6:55 30000.0
R6_50 M24:DRN 6:101 20089.3
R6_51 M24:DRN 6:62 59210.5
R6_52 M24:DRN 6:80 30000.0
R6_53 M3:GATE 6:40 7.57576
R6_54 M3:GATE 6:39 7.57576
R6_55 M4:GATE 6:35 7.57576
R6_56 M4:GATE 6:34 7.57576
R6_57 M5:GATE 6:30 7.57576
R6_58 M5:GATE 6:29 7.57576
R6_59 M6:GATE 6:26 7.57576
R6_60 M6:GATE 6:25 7.57576
R6_61 M7:SRC 6:65 30000.0
R6_62 M7:SRC 6:104 20270.3
R6_63 M7:SRC 6:58 57692.3
R6_64 M7:SRC 6:86 30000.0
R6_65 M8:DRN 6:65 30000.0
R6_66 M8:DRN 6:104 20270.3
R6_67 M8:DRN 6:58 57692.3
R6_68 M8:DRN 6:86 30000.0
R6_69 M9:SRC 6:63 30000.0
R6_70 M9:SRC 6:102 20270.3
R6_71 M9:SRC 6:56 57692.3
R6_72 M9:SRC 6:82 30000.0
R6_73 6:25 6:93 5.55556
R6_74 6:26 6:68 10.6061
R6_75 6:27 6:68 10.6061
R6_76 6:29 6:94 5.55556
R6_77 6:30 6:70 10.6061
R6_78 6:31 6:70 10.6061
R6_79 6:32 6:33 5.55556
R6_80 6:34 6:95 5.55556
R6_81 6:35 6:72 10.6061
R6_82 6:36 6:72 10.6061
R6_83 6:37 6:38 5.55556
R6_84 6:39 6:96 5.55556
R6_85 6:40 6:74 10.6061
R6_86 6:41 6:74 10.6061
R6_87 6:42 6:43 5.55556
R6_88 6:44 6:97 5.55556
R6_89 6:45 6:60 10.6061
R6_90 6:46 6:60 10.6061
R6_91 6:47 6:48 5.55556
R6_92 6:49 6:98 5.55556
R6_93 6:50 6:99 10.6061
R6_94 6:51 6:99 10.6061
R6_95 6:52 6:53 5.55556
R6_96 6:54 6:78 5.51634
R6_97 6:55 6:80 14.1199
R6_98 6:55 6:101 8.62446
R6_99 6:56 6:82 5.51634
R6_100 6:57 6:84 14.1199
R6_101 6:57 6:103 8.62446
R6_102 6:58 6:86 5.51634
R6_103 6:59 6:88 14.1199
R6_104 6:59 6:105 8.62446
R6_105 6:60 6:76 27.7339
R6_106 6:61 6:78 14.0605
R6_107 6:61 6:100 49500.0
R6_108 6:62 6:80 5.45702
R6_109 6:63 6:82 14.0605
R6_110 6:63 6:102 49500.0
R6_111 6:64 6:84 5.45702
R6_112 6:65 6:86 14.0605
R6_113 6:65 6:104 49500.0
R6_114 6:66 6:88 5.45702
R6_115 6:67 6:68 63.5281
R6_116 6:67 6:91 12.5416
R6_117 6:67 6:69 25.0832
R6_118 6:69 6:70 63.5281
R6_119 6:69 6:71 25.0832
R6_120 6:71 6:72 63.5281
R6_121 6:71 6:73 25.0832
R6_122 6:73 6:74 63.5281
R6_123 6:73 6:75 37.6249
R6_124 6:75 6:76 63.5281
R6_125 6:75 6:92 3.58332
R6_126 6:76 6:99 27.7339
R6_127 6:77 6:78 63.5281
R6_128 6:77 6:106 3.58332
R6_129 6:77 6:81 50.1665
R6_130 6:78 6:100 3.7634
R6_131 6:79 6:80 63.5281
R6_132 6:79 6:107 3.58332
R6_133 6:79 6:83 50.1665
R6_134 6:80 6:101 21900.0
R6_135 6:81 6:82 63.5281
R6_136 6:81 6:85 50.1665
R6_137 6:82 6:102 3.7634
R6_138 6:83 6:84 63.5281
R6_139 6:83 6:87 50.1665
R6_140 6:84 6:103 21900.0
R6_141 6:85 6:86 63.5281
R6_142 6:85 6:89 25.0832
R6_143 6:86 6:104 3.7634
R6_144 6:87 6:88 63.5281
R6_145 6:87 6:90 25.0832
R6_146 6:88 6:105 21900.0
R6_147 6:89 6:91 25.7999
R6_148 6:90 6:91 25.8596

*|NET 7 0PF
R7_1 7:1 7:2 109455.0

*|NET 8 0.00012552PF
C8_1 8:1 VSS:14 8.03136e-19
C8_2 8:1 VSS:15 8.03382e-19
C8_3 8:1 VSS:16 8.03382e-19
C8_4 8:1 VSS:17 8.03136e-19
C8_5 8:1 VSS:18 8.03382e-19
C8_6 8:1 VSS:28 9.31172e-20
C8_7 8:3 VSS:28 1.35956e-19
C8_8 8:1 VSS:36 2.26404e-18
C8_9 8:2 VSS:36 5.66869e-19
C8_10 8:3 VSS:36 3.20198e-20
C8_11 8:1 VSS:38 1.50868e-18
C8_12 8:1 VSS:39 1.50136e-18
C8_13 8:1 VSS:40 1.50868e-18
C8_14 8:1 VSS:41 1.50868e-18
C8_15 8:1 VSS:42 1.50136e-18
C8_16 8:1 VDD:14 8.0314e-19
C8_17 8:1 VDD:15 8.03418e-19
C8_18 8:1 VDD:16 8.03418e-19
C8_19 8:1 VDD:17 8.0314e-19
C8_20 8:1 VDD:18 8.03418e-19
C8_21 8:1 VDD:22 1.50126e-18
C8_22 8:1 VDD:24 1.50862e-18
C8_23 8:1 VDD:26 1.50862e-18
C8_24 8:1 VDD:28 1.50126e-18
C8_25 8:1 VDD:30 1.50862e-18
C8_26 8:1 VDD:32 3.47913e-19
C8_27 8:1 VDD:42 2.93789e-18
C8_28 8:1 Y:14 1.07714e-18
C8_29 8:1 Y:15 1.07721e-18
C8_30 8:1 Y:16 1.0432e-20
C8_31 8:2 Y:16 1.80413e-19
C8_32 8:1 Y:17 8.89477e-19
C8_33 8:1 Y:20 8.03382e-19
C8_34 8:1 Y:21 8.03418e-19
C8_35 8:1 Y:23 8.03418e-19
C8_36 8:1 Y:38 1.35803e-18
C8_37 8:2 Y:38 1.71771e-19
C8_38 8:3 Y:38 1.55906e-19
C8_39 8:1 Y:39 1.14871e-18
C8_40 8:1 6:54 1.07714e-18
C8_41 8:1 6:55 1.07721e-18
C8_42 8:1 6:56 1.07714e-18
C8_43 8:1 6:57 1.07721e-18
C8_44 8:1 6:58 1.06707e-18
C8_45 8:1 6:59 1.06709e-18
C8_46 8:1 6:60 5.41347e-21
C8_47 8:1 6:61 8.03382e-19
C8_48 8:1 6:62 8.03418e-19
C8_49 8:1 6:63 8.03382e-19
C8_50 8:1 6:64 8.03418e-19
C8_51 8:1 6:65 7.999e-19
C8_52 8:1 6:66 7.99905e-19
C8_53 8:1 6:89 1.22499e-18
C8_54 8:1 6:90 1.22511e-18
C8_55 8:1 6:91 7.27726e-19
C8_56 8:1 6:92 6.27997e-19
Cg8_57 8:1 VSS 6.73117e-17
Cg8_58 8:2 VSS 3.96707e-18
R8_1 8:1 8:2 10289.6
R8_2 8:2 8:3 1326.22

*|NET _generated_10 3.08088e-06PF
C9_1 _generated_10:1 VSS:28 1.47021e-19
C9_2 _generated_10:1 VDD:22 3.74453e-19
C9_3 _generated_10:1 VDD:34 1.18927e-19
C9_4 _generated_10:1 VDD:42 4.89892e-20
C9_5 _generated_10:1 A:55 3.15962e-19
C9_6 _generated_10:1 8:1 5.65589e-19
Cg9_7 _generated_10:1 VSS 9.3089e-19
R9_1 _generated_10:1 _generated_10:2 28.2828

*|NET _generated_11 5.37479e-06PF
C10_1 _generated_11:1 VSS:28 9.21148e-19
C10_2 _generated_11:1 VSS:36 9.68154e-20
C10_3 _generated_11:1 6:46 7.90108e-21
C10_4 _generated_11:1 6:49 1.58022e-21
C10_5 _generated_11:1 6:51 2.39886e-19
Cg10_6 _generated_11:1 VSS 3.50331e-18
R10_1 _generated_11:1 _generated_11:2 28.2828

*|NET _generated_12 5.0073e-06PF
C11_1 _generated_12:1 VDD:34 5.78695e-19
C11_2 _generated_12:1 VDD:42 1.91825e-19
C11_3 _generated_12:1 6:46 7.90108e-21
C11_4 _generated_12:1 6:51 2.39886e-19
C11_5 _generated_12:1 6:53 1.58022e-21
C11_6 _generated_12:1 _generated_11:1 6.0415e-19
Cg11_7 _generated_12:1 VSS 3.38326e-18
R11_1 _generated_12:1 _generated_12:2 28.2828

*|NET _generated_9 2.86348e-06PF
C12_1 _generated_9:1 VSS:36 2.25577e-20
C12_2 _generated_9:1 VSS:42 3.44976e-19
C12_3 _generated_9:1 A 3.06042e-19
C12_4 _generated_9:1 8:1 6.61239e-19
C12_5 _generated_9:1 _generated_10:1 5.79044e-19
Cg12_6 _generated_9:1 VSS 9.49624e-19
R12_1 _generated_9:1 _generated_9:2 28.2828

*
* Instance Section
*
MM1 M1:DRN M1:GATE M1:SRC VSS NMOS_LVT l=0.012u w=0.03u NF=1
MM10 M10:DRN M10:GATE M10:SRC VSS NMOS_LVT l=0.012u w=0.03u NF=1
MM11 M11:DRN M11:GATE M11:SRC VSS NMOS_LVT l=0.012u w=0.03u NF=1
MM12 M12:DRN M12:GATE M12:SRC VSS NMOS_LVT l=0.012u w=0.03u NF=1
MM13 M13:DRN M13:GATE M13:SRC VDD PMOS_LVT l=0.012u w=0.03u NF=1
MM14 M14:DRN M14:GATE M14:SRC VDD PMOS_LVT l=0.012u w=0.03u NF=1
MM15 M15:DRN M15:GATE M15:SRC VDD PMOS_LVT l=0.012u w=0.03u NF=1
MM16 M16:DRN M16:GATE M16:SRC VDD PMOS_LVT l=0.012u w=0.03u NF=1
MM17 M17:DRN M17:GATE M17:SRC VDD PMOS_LVT l=0.012u w=0.03u NF=1
MM18 M18:DRN M18:GATE M18:SRC VDD PMOS_LVT l=0.012u w=0.03u NF=1
MM19 M19:DRN M19:GATE M19:SRC VDD PMOS_LVT l=0.012u w=0.03u NF=1
MM2 M2:DRN M2:GATE M2:SRC VSS NMOS_LVT l=0.012u w=0.03u NF=1
MM20 M20:DRN M20:GATE M20:SRC VDD PMOS_LVT l=0.012u w=0.03u NF=1
MM21 M21:DRN M21:GATE M21:SRC VDD PMOS_LVT l=0.012u w=0.03u NF=1
MM22 M22:DRN M22:GATE M22:SRC VDD PMOS_LVT l=0.012u w=0.03u NF=1
MM23 M23:DRN M23:GATE M23:SRC VDD PMOS_LVT l=0.012u w=0.03u NF=1
MM24 M24:DRN M24:GATE M24:SRC VDD PMOS_LVT l=0.012u w=0.03u NF=1
MM3 M3:DRN M3:GATE M3:SRC VSS NMOS_LVT l=0.012u w=0.03u NF=1
MM4 M4:DRN M4:GATE M4:SRC VSS NMOS_LVT l=0.012u w=0.03u NF=1
MM5 M5:DRN M5:GATE M5:SRC VSS NMOS_LVT l=0.012u w=0.03u NF=1
MM6 M6:DRN M6:GATE M6:SRC VSS NMOS_LVT l=0.012u w=0.03u NF=1
MM7 M7:DRN M7:GATE M7:SRC VSS NMOS_LVT l=0.012u w=0.03u NF=1
MM8 M8:DRN M8:GATE M8:SRC VSS NMOS_LVT l=0.012u w=0.03u NF=1
MM9 M9:DRN M9:GATE M9:SRC VSS NMOS_LVT l=0.012u w=0.03u NF=1

.ENDS
