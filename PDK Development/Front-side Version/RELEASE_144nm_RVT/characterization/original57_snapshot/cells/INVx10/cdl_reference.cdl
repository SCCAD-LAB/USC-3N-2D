* CANDIDATE independent circuit from preserved2024 prior-layout DSPF.
* All resistive segments collapsed to ideal wires; capacitors omitted for LVS topology.
* Not extracted from the new144nmDUT. Requires independent review before gold admission.
* Source /cedar/cedar_coe/ece-limsk/sw.jung/pdk/LIB_issue_fix/final_w17_pdk/1_fspr/10_liberate_final_fspr_rvt/NETLIST/INVx10.spf
.SUBCKT INVx10 A VDD VSS Y
MMM18 Y A VSS nmos_rvt l=0.012u w=0.03u
MMM0 Y A VSS nmos_rvt l=0.012u w=0.03u
MMM19 Y A VDD pmos_rvt l=0.012u w=0.03u
MMM16 Y A VDD pmos_rvt l=0.012u w=0.03u
MMM15 Y A VDD pmos_rvt l=0.012u w=0.03u
MMM14 Y A VDD pmos_rvt l=0.012u w=0.03u
MMM13 Y A VDD pmos_rvt l=0.012u w=0.03u
MMM12 Y A VDD pmos_rvt l=0.012u w=0.03u
MMM11 Y A VDD pmos_rvt l=0.012u w=0.03u
MMM10 Y A VDD pmos_rvt l=0.012u w=0.03u
MMM9 Y A VDD pmos_rvt l=0.012u w=0.03u
MMM17 Y A VSS nmos_rvt l=0.012u w=0.03u
MMM8 Y A VDD pmos_rvt l=0.012u w=0.03u
MMM7 Y A VSS nmos_rvt l=0.012u w=0.03u
MMM6 Y A VSS nmos_rvt l=0.012u w=0.03u
MMM5 Y A VSS nmos_rvt l=0.012u w=0.03u
MMM4 Y A VSS nmos_rvt l=0.012u w=0.03u
MMM3 Y A VSS nmos_rvt l=0.012u w=0.03u
MMM2 Y A VSS nmos_rvt l=0.012u w=0.03u
MMM1 Y A VSS nmos_rvt l=0.012u w=0.03u
.ends INVx10
