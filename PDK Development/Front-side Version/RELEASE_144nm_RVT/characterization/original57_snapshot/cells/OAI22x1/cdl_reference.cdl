* CANDIDATE independent circuit from preserved2024 prior-layout DSPF.
* All resistive segments collapsed to ideal wires; capacitors omitted for LVS topology.
* Not extracted from the new144nmDUT. Requires independent review before gold admission.
* Source /cedar/cedar_coe/ece-limsk/sw.jung/pdk/LIB_issue_fix/final_w17_pdk/1_fspr/10_liberate_final_fspr_rvt/NETLIST/OAI22x1.spf
.SUBCKT OAI22x1 A B C D VDD VSS Y
MMM3 Y D MM0:DRN nmos_rvt l=0.012u w=0.03u
MMM2 Y C MM0:DRN nmos_rvt l=0.012u w=0.03u
MMM1 MM0:DRN B VSS nmos_rvt l=0.012u w=0.03u
MMM0 MM0:DRN A VSS nmos_rvt l=0.012u w=0.03u
MMM6 MM6:DRN D VDD pmos_rvt l=0.012u w=0.03u
MMM7 Y C MM6:DRN pmos_rvt l=0.012u w=0.03u
MMM5 Y B MM4:DRN pmos_rvt l=0.012u w=0.03u
MMM4 MM4:DRN A VDD pmos_rvt l=0.012u w=0.03u
.ends OAI22x1
