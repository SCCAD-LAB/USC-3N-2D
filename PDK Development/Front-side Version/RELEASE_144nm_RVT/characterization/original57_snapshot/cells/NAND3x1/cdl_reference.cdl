* CANDIDATE independent circuit from preserved2024 prior-layout DSPF.
* All resistive segments collapsed to ideal wires; capacitors omitted for LVS topology.
* Not extracted from the new144nmDUT. Requires independent review before gold admission.
* Source /cedar/cedar_coe/ece-limsk/sw.jung/pdk/LIB_issue_fix/final_w17_pdk/1_fspr/10_liberate_final_fspr_rvt/NETLIST/NAND3x1.spf
.SUBCKT NAND3x1 A B C VDD VSS Y
MMM2 Y C MM1:DRN nmos_rvt l=0.012u w=0.03u
MMM1 MM1:DRN B MM0:DRN nmos_rvt l=0.012u w=0.03u
MMM0 MM0:DRN A VSS nmos_rvt l=0.012u w=0.03u
MMM5 Y C VDD pmos_rvt l=0.012u w=0.03u
MMM4 Y B VDD pmos_rvt l=0.012u w=0.03u
MMM3 Y A VDD pmos_rvt l=0.012u w=0.03u
.ends NAND3x1
