* CANDIDATE independent circuit from preserved2024 prior-layout DSPF.
* All resistive segments collapsed to ideal wires; capacitors omitted for LVS topology.
* Not extracted from the new144nmDUT. Requires independent review before gold admission.
* Source /cedar/cedar_coe/ece-limsk/sw.jung/pdk/LIB_issue_fix/final_w17_pdk/1_fspr/10_liberate_final_fspr_rvt/NETLIST/XOR3x1.spf
.SUBCKT XOR3x1 A B C VDD VSS Y
MMM21 MM20:DRN C VSS VSS nmos_rvt l=0.012u w=0.03u
MMM9 Y MM14:GATE MM8:DRN VSS nmos_rvt l=0.012u w=0.03u
MMM8 MM8:DRN A VSS VSS nmos_rvt l=0.012u w=0.03u
MMM16 MM10:GATE A VSS VSS nmos_rvt l=0.012u w=0.03u
MMM20 MM20:DRN C VDD VDD pmos_rvt l=0.012u w=0.03u
MMM6 MM6:DRN C VDD VDD pmos_rvt l=0.012u w=0.03u
MMM7 MM14:GATE MM18:DRN MM6:DRN VDD pmos_rvt l=0.012u w=0.03u
MMM4 MM14:GATE MM20:DRN MM4:SRC VDD pmos_rvt l=0.012u w=0.03u
MMM5 MM4:SRC B VDD VDD pmos_rvt l=0.012u w=0.03u
MMM19 MM18:DRN B VDD VDD pmos_rvt l=0.012u w=0.03u
MMM22 MM11:GATE MM14:GATE VDD VDD pmos_rvt l=0.012u w=0.03u
MMM3 MM2:SRC MM20:DRN VSS VSS nmos_rvt l=0.012u w=0.03u
MMM14 MM14:DRN MM14:GATE VDD VDD pmos_rvt l=0.012u w=0.03u
MMM15 Y MM10:GATE MM14:DRN VDD pmos_rvt l=0.012u w=0.03u
MMM12 Y MM11:GATE MM12:SRC VDD pmos_rvt l=0.012u w=0.03u
MMM13 MM12:SRC A VDD VDD pmos_rvt l=0.012u w=0.03u
MMM17 MM10:GATE A VDD VDD pmos_rvt l=0.012u w=0.03u
MMM2 MM14:GATE MM18:DRN MM2:SRC VSS nmos_rvt l=0.012u w=0.03u
MMM1 MM14:GATE C MM0:DRN VSS nmos_rvt l=0.012u w=0.03u
MMM0 MM0:DRN B VSS VSS nmos_rvt l=0.012u w=0.03u
MMM18 MM18:DRN B VSS VSS nmos_rvt l=0.012u w=0.03u
MMM23 MM11:GATE MM14:GATE VSS VSS nmos_rvt l=0.012u w=0.03u
MMM11 MM10:SRC MM11:GATE VSS VSS nmos_rvt l=0.012u w=0.03u
MMM10 Y MM10:GATE MM10:SRC VSS nmos_rvt l=0.012u w=0.03u
.ends XOR3x1
