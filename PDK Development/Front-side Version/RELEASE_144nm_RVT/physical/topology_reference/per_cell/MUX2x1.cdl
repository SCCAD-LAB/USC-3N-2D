* CANDIDATE independent circuit from preserved2024 prior-layout DSPF.
* All resistive segments collapsed to ideal wires; capacitors omitted for LVS topology.
* Not extracted from the new144nmDUT. Requires independent review before gold admission.
* Source /cedar/cedar_coe/ece-limsk/sw.jung/pdk/LIB_issue_fix/final_w17_pdk/1_fspr/10_liberate_final_fspr_rvt/NETLIST/MUX2x1.spf
.SUBCKT MUX2x1 A B S VDD VSS Y
MMM9 Y B MM6:DRN VSS nmos_rvt l=0.012u w=0.03u
MMM3 Y A MM2:DRN VDD pmos_rvt l=0.012u w=0.03u
MMM8 Y MM0:DRN MM6:DRN VSS nmos_rvt l=0.012u w=0.03u
MMM0 MM0:DRN S VSS VSS nmos_rvt l=0.012u w=0.03u
MMM7 MM6:DRN S VSS VSS nmos_rvt l=0.012u w=0.03u
MMM6 MM6:DRN A VSS VSS nmos_rvt l=0.012u w=0.03u
MMM4 MM4:DRN B VDD VDD pmos_rvt l=0.012u w=0.03u
MMM5 Y MM0:DRN MM4:DRN VDD pmos_rvt l=0.012u w=0.03u
MMM1 MM0:DRN S VDD VDD pmos_rvt l=0.012u w=0.03u
MMM2 MM2:DRN S VDD VDD pmos_rvt l=0.012u w=0.03u
.ends MUX2x1
