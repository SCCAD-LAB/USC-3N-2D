* CANDIDATE independent circuit from preserved2024 prior-layout DSPF.
* All resistive segments collapsed to ideal wires; capacitors omitted for LVS topology.
* Not extracted from the new144nmDUT. Requires independent review before gold admission.
* Source /cedar/cedar_coe/ece-limsk/sw.jung/pdk/LIB_issue_fix/final_w17_pdk/1_fspr/10_liberate_final_fspr_rvt/NETLIST/OR2x1.spf
.SUBCKT OR2x1 A B VDD VSS Y
MMM5 Y MM0:DRN VSS VSS nmos_rvt l=0.012u w=0.03u
MMM1 MM0:DRN B VSS VSS nmos_rvt l=0.012u w=0.03u
MMM0 MM0:DRN A VSS VSS nmos_rvt l=0.012u w=0.03u
MMM4 Y MM0:DRN VDD VDD pmos_rvt l=0.012u w=0.03u
MMM3 MM0:DRN B MM2:DRN VDD pmos_rvt l=0.012u w=0.03u
MMM2 MM2:DRN A VDD VDD pmos_rvt l=0.012u w=0.03u
.ends OR2x1
