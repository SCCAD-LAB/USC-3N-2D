* CANDIDATE independent circuit from preserved2024 prior-layout DSPF.
* All resistive segments collapsed to ideal wires; capacitors omitted for LVS topology.
* Not extracted from the new144nmDUT. Requires independent review before gold admission.
* Source /cedar/cedar_coe/ece-limsk/sw.jung/pdk/LIB_issue_fix/final_w17_pdk/1_fspr/10_liberate_final_fspr_rvt/NETLIST/OAI222x1.spf
.SUBCKT OAI222x1 A B C D E F VDD VSS Y
MMM5 Y F MM2:DRN VSS nmos_rvt l=0.012u w=0.03u
MMM9 Y C MM8:DRN VDD pmos_rvt l=0.012u w=0.03u
MMM7 Y B MM6:DRN VDD pmos_rvt l=0.012u w=0.03u
MMM6 MM6:DRN A VDD VDD pmos_rvt l=0.012u w=0.03u
MMM4 Y E MM2:DRN VSS nmos_rvt l=0.012u w=0.03u
MMM3 MM2:DRN D MM0:DRN VSS nmos_rvt l=0.012u w=0.03u
MMM2 MM2:DRN C MM0:DRN VSS nmos_rvt l=0.012u w=0.03u
MMM1 MM0:DRN B VSS VSS nmos_rvt l=0.012u w=0.03u
MMM0 MM0:DRN A VSS VSS nmos_rvt l=0.012u w=0.03u
MMM11 Y F MM10:DRN VDD pmos_rvt l=0.012u w=0.03u
MMM10 MM10:DRN E VDD VDD pmos_rvt l=0.012u w=0.03u
MMM8 MM8:DRN D VDD VDD pmos_rvt l=0.012u w=0.03u
.ends OAI222x1
