* CANDIDATE independent circuit from preserved2024 prior-layout DSPF.
* All resistive segments collapsed to ideal wires; capacitors omitted for LVS topology.
* Not extracted from the new144nmDUT. Requires independent review before gold admission.
* Source /cedar/cedar_coe/ece-limsk/sw.jung/pdk/LIB_issue_fix/final_w17_pdk/1_fspr/10_liberate_final_fspr_rvt/NETLIST/XNOR2x1.spf
.SUBCKT XNOR2x1 A B VDD VSS Y
MMM11 MM11:DRN B VSS VSS nmos_rvt l=0.012u w=0.03u
MMM4 Y B MM4:SRC VDD pmos_rvt l=0.012u w=0.03u
MMM5 MM4:SRC A VDD VDD pmos_rvt l=0.012u w=0.03u
MMM9 MM10:DRN A VDD VDD pmos_rvt l=0.012u w=0.03u
MMM2 MM2:DRN B VSS VSS nmos_rvt l=0.012u w=0.03u
MMM3 Y MM10:DRN MM2:DRN VSS nmos_rvt l=0.012u w=0.03u
MMM1 Y MM11:DRN MM0:DRN VSS nmos_rvt l=0.012u w=0.03u
MMM0 MM0:DRN A VSS VSS nmos_rvt l=0.012u w=0.03u
MMM10 MM10:DRN A VSS VSS nmos_rvt l=0.012u w=0.03u
MMM8 MM11:DRN B VDD VDD pmos_rvt l=0.012u w=0.03u
MMM7 MM6:SRC MM11:DRN VDD VDD pmos_rvt l=0.012u w=0.03u
MMM6 Y MM10:DRN MM6:SRC VDD pmos_rvt l=0.012u w=0.03u
.ends XNOR2x1
