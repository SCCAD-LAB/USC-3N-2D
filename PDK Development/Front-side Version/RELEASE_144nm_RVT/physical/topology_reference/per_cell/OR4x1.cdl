* CANDIDATE independent circuit from preserved2024 prior-layout DSPF.
* All resistive segments collapsed to ideal wires; capacitors omitted for LVS topology.
* Not extracted from the new144nmDUT. Requires independent review before gold admission.
* Source /cedar/cedar_coe/ece-limsk/sw.jung/pdk/LIB_issue_fix/final_w17_pdk/1_fspr/10_liberate_final_fspr_rvt/NETLIST/OR4x1.spf
.SUBCKT OR4x1 A B C D VDD VSS Y
MMM9 Y MM0:DRN VSS VSS nmos_rvt l=0.012u w=0.03u
MMM7 MM6:SRC A VDD VDD pmos_rvt l=0.012u w=0.03u
MMM3 MM0:DRN D VSS VSS nmos_rvt l=0.012u w=0.03u
MMM2 MM0:DRN C VSS VSS nmos_rvt l=0.012u w=0.03u
MMM1 MM0:DRN B VSS VSS nmos_rvt l=0.012u w=0.03u
MMM0 MM0:DRN A VSS VSS nmos_rvt l=0.012u w=0.03u
MMM8 Y MM0:DRN VDD VDD pmos_rvt l=0.012u w=0.03u
MMM4 MM0:DRN D MM4:SRC VDD pmos_rvt l=0.012u w=0.03u
MMM5 MM4:SRC C MM5:SRC VDD pmos_rvt l=0.012u w=0.03u
MMM6 MM5:SRC B MM6:SRC VDD pmos_rvt l=0.012u w=0.03u
.ends OR4x1
