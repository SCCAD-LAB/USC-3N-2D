* CANDIDATE independent circuit from preserved2024 prior-layout DSPF.
* All resistive segments collapsed to ideal wires; capacitors omitted for LVS topology.
* Not extracted from the new144nmDUT. Requires independent review before gold admission.
* Source /cedar/cedar_coe/ece-limsk/sw.jung/pdk/LIB_issue_fix/final_w17_pdk/1_fspr/10_liberate_final_fspr_rvt/NETLIST/AOI221x1.spf
.SUBCKT AOI221x1 A B C D E VDD VSS Y
MMM3 Y D MM3:SRC VSS nmos_rvt l=0.012u w=0.03u
MMM5 MM5:DRN A VDD VDD pmos_rvt l=0.012u w=0.03u
MMM4 MM3:SRC C VSS VSS nmos_rvt l=0.012u w=0.03u
MMM2 Y E VSS VSS nmos_rvt l=0.012u w=0.03u
MMM1 Y B MM0:DRN VSS nmos_rvt l=0.012u w=0.03u
MMM0 MM0:DRN A VSS VSS nmos_rvt l=0.012u w=0.03u
MMM9 Y D MM7:DRN VDD pmos_rvt l=0.012u w=0.03u
MMM8 Y C MM7:DRN VDD pmos_rvt l=0.012u w=0.03u
MMM7 MM7:DRN E MM5:DRN VDD pmos_rvt l=0.012u w=0.03u
MMM6 MM5:DRN B VDD VDD pmos_rvt l=0.012u w=0.03u
.ends AOI221x1
